* CDL Netlist generated by OpenROAD

*.BUSDELIMITER [

.SUBCKT Sync_FIFO_async_rst clk din[0] din[1] din[2] din[3]
+ din[4] din[5] din[6] din[7] dout[0] dout[1] dout[2] dout[3]
+ dout[4] dout[5] dout[6] dout[7] empty full rd_en rst wr_en
XPHY_EDGE_ROW_0_Left_39 _unconnected_0 _unconnected_1 _unconnected_2
+ _unconnected_3 sky130_fd_sc_hd__decap_3
XPHY_EDGE_ROW_0_Right_0 _unconnected_4 _unconnected_5 _unconnected_6
+ _unconnected_7 sky130_fd_sc_hd__decap_3
XPHY_EDGE_ROW_10_Left_49 _unconnected_8 _unconnected_9 _unconnected_10
+ _unconnected_11 sky130_fd_sc_hd__decap_3
XPHY_EDGE_ROW_10_Right_10 _unconnected_12 _unconnected_13
+ _unconnected_14 _unconnected_15 sky130_fd_sc_hd__decap_3
XPHY_EDGE_ROW_11_Left_50 _unconnected_16 _unconnected_17 _unconnected_18
+ _unconnected_19 sky130_fd_sc_hd__decap_3
XPHY_EDGE_ROW_11_Right_11 _unconnected_20 _unconnected_21
+ _unconnected_22 _unconnected_23 sky130_fd_sc_hd__decap_3
XPHY_EDGE_ROW_12_Left_51 _unconnected_24 _unconnected_25 _unconnected_26
+ _unconnected_27 sky130_fd_sc_hd__decap_3
XPHY_EDGE_ROW_12_Right_12 _unconnected_28 _unconnected_29
+ _unconnected_30 _unconnected_31 sky130_fd_sc_hd__decap_3
XPHY_EDGE_ROW_13_Left_52 _unconnected_32 _unconnected_33 _unconnected_34
+ _unconnected_35 sky130_fd_sc_hd__decap_3
XPHY_EDGE_ROW_13_Right_13 _unconnected_36 _unconnected_37
+ _unconnected_38 _unconnected_39 sky130_fd_sc_hd__decap_3
XPHY_EDGE_ROW_14_Left_53 _unconnected_40 _unconnected_41 _unconnected_42
+ _unconnected_43 sky130_fd_sc_hd__decap_3
XPHY_EDGE_ROW_14_Right_14 _unconnected_44 _unconnected_45
+ _unconnected_46 _unconnected_47 sky130_fd_sc_hd__decap_3
XPHY_EDGE_ROW_15_Left_54 _unconnected_48 _unconnected_49 _unconnected_50
+ _unconnected_51 sky130_fd_sc_hd__decap_3
XPHY_EDGE_ROW_15_Right_15 _unconnected_52 _unconnected_53
+ _unconnected_54 _unconnected_55 sky130_fd_sc_hd__decap_3
XPHY_EDGE_ROW_16_Left_55 _unconnected_56 _unconnected_57 _unconnected_58
+ _unconnected_59 sky130_fd_sc_hd__decap_3
XPHY_EDGE_ROW_16_Right_16 _unconnected_60 _unconnected_61
+ _unconnected_62 _unconnected_63 sky130_fd_sc_hd__decap_3
XPHY_EDGE_ROW_17_Left_56 _unconnected_64 _unconnected_65 _unconnected_66
+ _unconnected_67 sky130_fd_sc_hd__decap_3
XPHY_EDGE_ROW_17_Right_17 _unconnected_68 _unconnected_69
+ _unconnected_70 _unconnected_71 sky130_fd_sc_hd__decap_3
XPHY_EDGE_ROW_18_Left_57 _unconnected_72 _unconnected_73 _unconnected_74
+ _unconnected_75 sky130_fd_sc_hd__decap_3
XPHY_EDGE_ROW_18_Right_18 _unconnected_76 _unconnected_77
+ _unconnected_78 _unconnected_79 sky130_fd_sc_hd__decap_3
XPHY_EDGE_ROW_19_Left_58 _unconnected_80 _unconnected_81 _unconnected_82
+ _unconnected_83 sky130_fd_sc_hd__decap_3
XPHY_EDGE_ROW_19_Right_19 _unconnected_84 _unconnected_85
+ _unconnected_86 _unconnected_87 sky130_fd_sc_hd__decap_3
XPHY_EDGE_ROW_1_Left_40 _unconnected_88 _unconnected_89 _unconnected_90
+ _unconnected_91 sky130_fd_sc_hd__decap_3
XPHY_EDGE_ROW_1_Right_1 _unconnected_92 _unconnected_93 _unconnected_94
+ _unconnected_95 sky130_fd_sc_hd__decap_3
XPHY_EDGE_ROW_20_Left_59 _unconnected_96 _unconnected_97 _unconnected_98
+ _unconnected_99 sky130_fd_sc_hd__decap_3
XPHY_EDGE_ROW_20_Right_20 _unconnected_100 _unconnected_101
+ _unconnected_102 _unconnected_103 sky130_fd_sc_hd__decap_3
XPHY_EDGE_ROW_21_Left_60 _unconnected_104 _unconnected_105
+ _unconnected_106 _unconnected_107 sky130_fd_sc_hd__decap_3
XPHY_EDGE_ROW_21_Right_21 _unconnected_108 _unconnected_109
+ _unconnected_110 _unconnected_111 sky130_fd_sc_hd__decap_3
XPHY_EDGE_ROW_22_Left_61 _unconnected_112 _unconnected_113
+ _unconnected_114 _unconnected_115 sky130_fd_sc_hd__decap_3
XPHY_EDGE_ROW_22_Right_22 _unconnected_116 _unconnected_117
+ _unconnected_118 _unconnected_119 sky130_fd_sc_hd__decap_3
XPHY_EDGE_ROW_23_Left_62 _unconnected_120 _unconnected_121
+ _unconnected_122 _unconnected_123 sky130_fd_sc_hd__decap_3
XPHY_EDGE_ROW_23_Right_23 _unconnected_124 _unconnected_125
+ _unconnected_126 _unconnected_127 sky130_fd_sc_hd__decap_3
XPHY_EDGE_ROW_24_Left_63 _unconnected_128 _unconnected_129
+ _unconnected_130 _unconnected_131 sky130_fd_sc_hd__decap_3
XPHY_EDGE_ROW_24_Right_24 _unconnected_132 _unconnected_133
+ _unconnected_134 _unconnected_135 sky130_fd_sc_hd__decap_3
XPHY_EDGE_ROW_25_Left_64 _unconnected_136 _unconnected_137
+ _unconnected_138 _unconnected_139 sky130_fd_sc_hd__decap_3
XPHY_EDGE_ROW_25_Right_25 _unconnected_140 _unconnected_141
+ _unconnected_142 _unconnected_143 sky130_fd_sc_hd__decap_3
XPHY_EDGE_ROW_26_Left_65 _unconnected_144 _unconnected_145
+ _unconnected_146 _unconnected_147 sky130_fd_sc_hd__decap_3
XPHY_EDGE_ROW_26_Right_26 _unconnected_148 _unconnected_149
+ _unconnected_150 _unconnected_151 sky130_fd_sc_hd__decap_3
XPHY_EDGE_ROW_27_Left_66 _unconnected_152 _unconnected_153
+ _unconnected_154 _unconnected_155 sky130_fd_sc_hd__decap_3
XPHY_EDGE_ROW_27_Right_27 _unconnected_156 _unconnected_157
+ _unconnected_158 _unconnected_159 sky130_fd_sc_hd__decap_3
XPHY_EDGE_ROW_28_Left_67 _unconnected_160 _unconnected_161
+ _unconnected_162 _unconnected_163 sky130_fd_sc_hd__decap_3
XPHY_EDGE_ROW_28_Right_28 _unconnected_164 _unconnected_165
+ _unconnected_166 _unconnected_167 sky130_fd_sc_hd__decap_3
XPHY_EDGE_ROW_29_Left_68 _unconnected_168 _unconnected_169
+ _unconnected_170 _unconnected_171 sky130_fd_sc_hd__decap_3
XPHY_EDGE_ROW_29_Right_29 _unconnected_172 _unconnected_173
+ _unconnected_174 _unconnected_175 sky130_fd_sc_hd__decap_3
XPHY_EDGE_ROW_2_Left_41 _unconnected_176 _unconnected_177
+ _unconnected_178 _unconnected_179 sky130_fd_sc_hd__decap_3
XPHY_EDGE_ROW_2_Right_2 _unconnected_180 _unconnected_181
+ _unconnected_182 _unconnected_183 sky130_fd_sc_hd__decap_3
XPHY_EDGE_ROW_30_Left_69 _unconnected_184 _unconnected_185
+ _unconnected_186 _unconnected_187 sky130_fd_sc_hd__decap_3
XPHY_EDGE_ROW_30_Right_30 _unconnected_188 _unconnected_189
+ _unconnected_190 _unconnected_191 sky130_fd_sc_hd__decap_3
XPHY_EDGE_ROW_31_Left_70 _unconnected_192 _unconnected_193
+ _unconnected_194 _unconnected_195 sky130_fd_sc_hd__decap_3
XPHY_EDGE_ROW_31_Right_31 _unconnected_196 _unconnected_197
+ _unconnected_198 _unconnected_199 sky130_fd_sc_hd__decap_3
XPHY_EDGE_ROW_32_Left_71 _unconnected_200 _unconnected_201
+ _unconnected_202 _unconnected_203 sky130_fd_sc_hd__decap_3
XPHY_EDGE_ROW_32_Right_32 _unconnected_204 _unconnected_205
+ _unconnected_206 _unconnected_207 sky130_fd_sc_hd__decap_3
XPHY_EDGE_ROW_33_Left_72 _unconnected_208 _unconnected_209
+ _unconnected_210 _unconnected_211 sky130_fd_sc_hd__decap_3
XPHY_EDGE_ROW_33_Right_33 _unconnected_212 _unconnected_213
+ _unconnected_214 _unconnected_215 sky130_fd_sc_hd__decap_3
XPHY_EDGE_ROW_34_Left_73 _unconnected_216 _unconnected_217
+ _unconnected_218 _unconnected_219 sky130_fd_sc_hd__decap_3
XPHY_EDGE_ROW_34_Right_34 _unconnected_220 _unconnected_221
+ _unconnected_222 _unconnected_223 sky130_fd_sc_hd__decap_3
XPHY_EDGE_ROW_35_Left_74 _unconnected_224 _unconnected_225
+ _unconnected_226 _unconnected_227 sky130_fd_sc_hd__decap_3
XPHY_EDGE_ROW_35_Right_35 _unconnected_228 _unconnected_229
+ _unconnected_230 _unconnected_231 sky130_fd_sc_hd__decap_3
XPHY_EDGE_ROW_36_Left_75 _unconnected_232 _unconnected_233
+ _unconnected_234 _unconnected_235 sky130_fd_sc_hd__decap_3
XPHY_EDGE_ROW_36_Right_36 _unconnected_236 _unconnected_237
+ _unconnected_238 _unconnected_239 sky130_fd_sc_hd__decap_3
XPHY_EDGE_ROW_37_Left_76 _unconnected_240 _unconnected_241
+ _unconnected_242 _unconnected_243 sky130_fd_sc_hd__decap_3
XPHY_EDGE_ROW_37_Right_37 _unconnected_244 _unconnected_245
+ _unconnected_246 _unconnected_247 sky130_fd_sc_hd__decap_3
XPHY_EDGE_ROW_38_Left_77 _unconnected_248 _unconnected_249
+ _unconnected_250 _unconnected_251 sky130_fd_sc_hd__decap_3
XPHY_EDGE_ROW_38_Right_38 _unconnected_252 _unconnected_253
+ _unconnected_254 _unconnected_255 sky130_fd_sc_hd__decap_3
XPHY_EDGE_ROW_3_Left_42 _unconnected_256 _unconnected_257
+ _unconnected_258 _unconnected_259 sky130_fd_sc_hd__decap_3
XPHY_EDGE_ROW_3_Right_3 _unconnected_260 _unconnected_261
+ _unconnected_262 _unconnected_263 sky130_fd_sc_hd__decap_3
XPHY_EDGE_ROW_4_Left_43 _unconnected_264 _unconnected_265
+ _unconnected_266 _unconnected_267 sky130_fd_sc_hd__decap_3
XPHY_EDGE_ROW_4_Right_4 _unconnected_268 _unconnected_269
+ _unconnected_270 _unconnected_271 sky130_fd_sc_hd__decap_3
XPHY_EDGE_ROW_5_Left_44 _unconnected_272 _unconnected_273
+ _unconnected_274 _unconnected_275 sky130_fd_sc_hd__decap_3
XPHY_EDGE_ROW_5_Right_5 _unconnected_276 _unconnected_277
+ _unconnected_278 _unconnected_279 sky130_fd_sc_hd__decap_3
XPHY_EDGE_ROW_6_Left_45 _unconnected_280 _unconnected_281
+ _unconnected_282 _unconnected_283 sky130_fd_sc_hd__decap_3
XPHY_EDGE_ROW_6_Right_6 _unconnected_284 _unconnected_285
+ _unconnected_286 _unconnected_287 sky130_fd_sc_hd__decap_3
XPHY_EDGE_ROW_7_Left_46 _unconnected_288 _unconnected_289
+ _unconnected_290 _unconnected_291 sky130_fd_sc_hd__decap_3
XPHY_EDGE_ROW_7_Right_7 _unconnected_292 _unconnected_293
+ _unconnected_294 _unconnected_295 sky130_fd_sc_hd__decap_3
XPHY_EDGE_ROW_8_Left_47 _unconnected_296 _unconnected_297
+ _unconnected_298 _unconnected_299 sky130_fd_sc_hd__decap_3
XPHY_EDGE_ROW_8_Right_8 _unconnected_300 _unconnected_301
+ _unconnected_302 _unconnected_303 sky130_fd_sc_hd__decap_3
XPHY_EDGE_ROW_9_Left_48 _unconnected_304 _unconnected_305
+ _unconnected_306 _unconnected_307 sky130_fd_sc_hd__decap_3
XPHY_EDGE_ROW_9_Right_9 _unconnected_308 _unconnected_309
+ _unconnected_310 _unconnected_311 sky130_fd_sc_hd__decap_3
XTAP_TAPCELL_ROW_0_78 _unconnected_312 _unconnected_313 sky130_fd_sc_hd__tapvpwrvgnd_1
XTAP_TAPCELL_ROW_0_79 _unconnected_314 _unconnected_315 sky130_fd_sc_hd__tapvpwrvgnd_1
XTAP_TAPCELL_ROW_0_80 _unconnected_316 _unconnected_317 sky130_fd_sc_hd__tapvpwrvgnd_1
XTAP_TAPCELL_ROW_0_81 _unconnected_318 _unconnected_319 sky130_fd_sc_hd__tapvpwrvgnd_1
XTAP_TAPCELL_ROW_0_82 _unconnected_320 _unconnected_321 sky130_fd_sc_hd__tapvpwrvgnd_1
XTAP_TAPCELL_ROW_0_83 _unconnected_322 _unconnected_323 sky130_fd_sc_hd__tapvpwrvgnd_1
XTAP_TAPCELL_ROW_0_84 _unconnected_324 _unconnected_325 sky130_fd_sc_hd__tapvpwrvgnd_1
XTAP_TAPCELL_ROW_10_116 _unconnected_326 _unconnected_327
+ sky130_fd_sc_hd__tapvpwrvgnd_1
XTAP_TAPCELL_ROW_10_117 _unconnected_328 _unconnected_329
+ sky130_fd_sc_hd__tapvpwrvgnd_1
XTAP_TAPCELL_ROW_10_118 _unconnected_330 _unconnected_331
+ sky130_fd_sc_hd__tapvpwrvgnd_1
XTAP_TAPCELL_ROW_10_119 _unconnected_332 _unconnected_333
+ sky130_fd_sc_hd__tapvpwrvgnd_1
XTAP_TAPCELL_ROW_11_120 _unconnected_334 _unconnected_335
+ sky130_fd_sc_hd__tapvpwrvgnd_1
XTAP_TAPCELL_ROW_11_121 _unconnected_336 _unconnected_337
+ sky130_fd_sc_hd__tapvpwrvgnd_1
XTAP_TAPCELL_ROW_11_122 _unconnected_338 _unconnected_339
+ sky130_fd_sc_hd__tapvpwrvgnd_1
XTAP_TAPCELL_ROW_12_123 _unconnected_340 _unconnected_341
+ sky130_fd_sc_hd__tapvpwrvgnd_1
XTAP_TAPCELL_ROW_12_124 _unconnected_342 _unconnected_343
+ sky130_fd_sc_hd__tapvpwrvgnd_1
XTAP_TAPCELL_ROW_12_125 _unconnected_344 _unconnected_345
+ sky130_fd_sc_hd__tapvpwrvgnd_1
XTAP_TAPCELL_ROW_12_126 _unconnected_346 _unconnected_347
+ sky130_fd_sc_hd__tapvpwrvgnd_1
XTAP_TAPCELL_ROW_13_127 _unconnected_348 _unconnected_349
+ sky130_fd_sc_hd__tapvpwrvgnd_1
XTAP_TAPCELL_ROW_13_128 _unconnected_350 _unconnected_351
+ sky130_fd_sc_hd__tapvpwrvgnd_1
XTAP_TAPCELL_ROW_13_129 _unconnected_352 _unconnected_353
+ sky130_fd_sc_hd__tapvpwrvgnd_1
XTAP_TAPCELL_ROW_14_130 _unconnected_354 _unconnected_355
+ sky130_fd_sc_hd__tapvpwrvgnd_1
XTAP_TAPCELL_ROW_14_131 _unconnected_356 _unconnected_357
+ sky130_fd_sc_hd__tapvpwrvgnd_1
XTAP_TAPCELL_ROW_14_132 _unconnected_358 _unconnected_359
+ sky130_fd_sc_hd__tapvpwrvgnd_1
XTAP_TAPCELL_ROW_14_133 _unconnected_360 _unconnected_361
+ sky130_fd_sc_hd__tapvpwrvgnd_1
XTAP_TAPCELL_ROW_15_134 _unconnected_362 _unconnected_363
+ sky130_fd_sc_hd__tapvpwrvgnd_1
XTAP_TAPCELL_ROW_15_135 _unconnected_364 _unconnected_365
+ sky130_fd_sc_hd__tapvpwrvgnd_1
XTAP_TAPCELL_ROW_15_136 _unconnected_366 _unconnected_367
+ sky130_fd_sc_hd__tapvpwrvgnd_1
XTAP_TAPCELL_ROW_16_137 _unconnected_368 _unconnected_369
+ sky130_fd_sc_hd__tapvpwrvgnd_1
XTAP_TAPCELL_ROW_16_138 _unconnected_370 _unconnected_371
+ sky130_fd_sc_hd__tapvpwrvgnd_1
XTAP_TAPCELL_ROW_16_139 _unconnected_372 _unconnected_373
+ sky130_fd_sc_hd__tapvpwrvgnd_1
XTAP_TAPCELL_ROW_16_140 _unconnected_374 _unconnected_375
+ sky130_fd_sc_hd__tapvpwrvgnd_1
XTAP_TAPCELL_ROW_17_141 _unconnected_376 _unconnected_377
+ sky130_fd_sc_hd__tapvpwrvgnd_1
XTAP_TAPCELL_ROW_17_142 _unconnected_378 _unconnected_379
+ sky130_fd_sc_hd__tapvpwrvgnd_1
XTAP_TAPCELL_ROW_17_143 _unconnected_380 _unconnected_381
+ sky130_fd_sc_hd__tapvpwrvgnd_1
XTAP_TAPCELL_ROW_18_144 _unconnected_382 _unconnected_383
+ sky130_fd_sc_hd__tapvpwrvgnd_1
XTAP_TAPCELL_ROW_18_145 _unconnected_384 _unconnected_385
+ sky130_fd_sc_hd__tapvpwrvgnd_1
XTAP_TAPCELL_ROW_18_146 _unconnected_386 _unconnected_387
+ sky130_fd_sc_hd__tapvpwrvgnd_1
XTAP_TAPCELL_ROW_18_147 _unconnected_388 _unconnected_389
+ sky130_fd_sc_hd__tapvpwrvgnd_1
XTAP_TAPCELL_ROW_19_148 _unconnected_390 _unconnected_391
+ sky130_fd_sc_hd__tapvpwrvgnd_1
XTAP_TAPCELL_ROW_19_149 _unconnected_392 _unconnected_393
+ sky130_fd_sc_hd__tapvpwrvgnd_1
XTAP_TAPCELL_ROW_19_150 _unconnected_394 _unconnected_395
+ sky130_fd_sc_hd__tapvpwrvgnd_1
XTAP_TAPCELL_ROW_1_85 _unconnected_396 _unconnected_397 sky130_fd_sc_hd__tapvpwrvgnd_1
XTAP_TAPCELL_ROW_1_86 _unconnected_398 _unconnected_399 sky130_fd_sc_hd__tapvpwrvgnd_1
XTAP_TAPCELL_ROW_1_87 _unconnected_400 _unconnected_401 sky130_fd_sc_hd__tapvpwrvgnd_1
XTAP_TAPCELL_ROW_20_151 _unconnected_402 _unconnected_403
+ sky130_fd_sc_hd__tapvpwrvgnd_1
XTAP_TAPCELL_ROW_20_152 _unconnected_404 _unconnected_405
+ sky130_fd_sc_hd__tapvpwrvgnd_1
XTAP_TAPCELL_ROW_20_153 _unconnected_406 _unconnected_407
+ sky130_fd_sc_hd__tapvpwrvgnd_1
XTAP_TAPCELL_ROW_20_154 _unconnected_408 _unconnected_409
+ sky130_fd_sc_hd__tapvpwrvgnd_1
XTAP_TAPCELL_ROW_21_155 _unconnected_410 _unconnected_411
+ sky130_fd_sc_hd__tapvpwrvgnd_1
XTAP_TAPCELL_ROW_21_156 _unconnected_412 _unconnected_413
+ sky130_fd_sc_hd__tapvpwrvgnd_1
XTAP_TAPCELL_ROW_21_157 _unconnected_414 _unconnected_415
+ sky130_fd_sc_hd__tapvpwrvgnd_1
XTAP_TAPCELL_ROW_22_158 _unconnected_416 _unconnected_417
+ sky130_fd_sc_hd__tapvpwrvgnd_1
XTAP_TAPCELL_ROW_22_159 _unconnected_418 _unconnected_419
+ sky130_fd_sc_hd__tapvpwrvgnd_1
XTAP_TAPCELL_ROW_22_160 _unconnected_420 _unconnected_421
+ sky130_fd_sc_hd__tapvpwrvgnd_1
XTAP_TAPCELL_ROW_22_161 _unconnected_422 _unconnected_423
+ sky130_fd_sc_hd__tapvpwrvgnd_1
XTAP_TAPCELL_ROW_23_162 _unconnected_424 _unconnected_425
+ sky130_fd_sc_hd__tapvpwrvgnd_1
XTAP_TAPCELL_ROW_23_163 _unconnected_426 _unconnected_427
+ sky130_fd_sc_hd__tapvpwrvgnd_1
XTAP_TAPCELL_ROW_23_164 _unconnected_428 _unconnected_429
+ sky130_fd_sc_hd__tapvpwrvgnd_1
XTAP_TAPCELL_ROW_24_165 _unconnected_430 _unconnected_431
+ sky130_fd_sc_hd__tapvpwrvgnd_1
XTAP_TAPCELL_ROW_24_166 _unconnected_432 _unconnected_433
+ sky130_fd_sc_hd__tapvpwrvgnd_1
XTAP_TAPCELL_ROW_24_167 _unconnected_434 _unconnected_435
+ sky130_fd_sc_hd__tapvpwrvgnd_1
XTAP_TAPCELL_ROW_24_168 _unconnected_436 _unconnected_437
+ sky130_fd_sc_hd__tapvpwrvgnd_1
XTAP_TAPCELL_ROW_25_169 _unconnected_438 _unconnected_439
+ sky130_fd_sc_hd__tapvpwrvgnd_1
XTAP_TAPCELL_ROW_25_170 _unconnected_440 _unconnected_441
+ sky130_fd_sc_hd__tapvpwrvgnd_1
XTAP_TAPCELL_ROW_25_171 _unconnected_442 _unconnected_443
+ sky130_fd_sc_hd__tapvpwrvgnd_1
XTAP_TAPCELL_ROW_26_172 _unconnected_444 _unconnected_445
+ sky130_fd_sc_hd__tapvpwrvgnd_1
XTAP_TAPCELL_ROW_26_173 _unconnected_446 _unconnected_447
+ sky130_fd_sc_hd__tapvpwrvgnd_1
XTAP_TAPCELL_ROW_26_174 _unconnected_448 _unconnected_449
+ sky130_fd_sc_hd__tapvpwrvgnd_1
XTAP_TAPCELL_ROW_26_175 _unconnected_450 _unconnected_451
+ sky130_fd_sc_hd__tapvpwrvgnd_1
XTAP_TAPCELL_ROW_27_176 _unconnected_452 _unconnected_453
+ sky130_fd_sc_hd__tapvpwrvgnd_1
XTAP_TAPCELL_ROW_27_177 _unconnected_454 _unconnected_455
+ sky130_fd_sc_hd__tapvpwrvgnd_1
XTAP_TAPCELL_ROW_27_178 _unconnected_456 _unconnected_457
+ sky130_fd_sc_hd__tapvpwrvgnd_1
XTAP_TAPCELL_ROW_28_179 _unconnected_458 _unconnected_459
+ sky130_fd_sc_hd__tapvpwrvgnd_1
XTAP_TAPCELL_ROW_28_180 _unconnected_460 _unconnected_461
+ sky130_fd_sc_hd__tapvpwrvgnd_1
XTAP_TAPCELL_ROW_28_181 _unconnected_462 _unconnected_463
+ sky130_fd_sc_hd__tapvpwrvgnd_1
XTAP_TAPCELL_ROW_28_182 _unconnected_464 _unconnected_465
+ sky130_fd_sc_hd__tapvpwrvgnd_1
XTAP_TAPCELL_ROW_29_183 _unconnected_466 _unconnected_467
+ sky130_fd_sc_hd__tapvpwrvgnd_1
XTAP_TAPCELL_ROW_29_184 _unconnected_468 _unconnected_469
+ sky130_fd_sc_hd__tapvpwrvgnd_1
XTAP_TAPCELL_ROW_29_185 _unconnected_470 _unconnected_471
+ sky130_fd_sc_hd__tapvpwrvgnd_1
XTAP_TAPCELL_ROW_2_88 _unconnected_472 _unconnected_473 sky130_fd_sc_hd__tapvpwrvgnd_1
XTAP_TAPCELL_ROW_2_89 _unconnected_474 _unconnected_475 sky130_fd_sc_hd__tapvpwrvgnd_1
XTAP_TAPCELL_ROW_2_90 _unconnected_476 _unconnected_477 sky130_fd_sc_hd__tapvpwrvgnd_1
XTAP_TAPCELL_ROW_2_91 _unconnected_478 _unconnected_479 sky130_fd_sc_hd__tapvpwrvgnd_1
XTAP_TAPCELL_ROW_30_186 _unconnected_480 _unconnected_481
+ sky130_fd_sc_hd__tapvpwrvgnd_1
XTAP_TAPCELL_ROW_30_187 _unconnected_482 _unconnected_483
+ sky130_fd_sc_hd__tapvpwrvgnd_1
XTAP_TAPCELL_ROW_30_188 _unconnected_484 _unconnected_485
+ sky130_fd_sc_hd__tapvpwrvgnd_1
XTAP_TAPCELL_ROW_30_189 _unconnected_486 _unconnected_487
+ sky130_fd_sc_hd__tapvpwrvgnd_1
XTAP_TAPCELL_ROW_31_190 _unconnected_488 _unconnected_489
+ sky130_fd_sc_hd__tapvpwrvgnd_1
XTAP_TAPCELL_ROW_31_191 _unconnected_490 _unconnected_491
+ sky130_fd_sc_hd__tapvpwrvgnd_1
XTAP_TAPCELL_ROW_31_192 _unconnected_492 _unconnected_493
+ sky130_fd_sc_hd__tapvpwrvgnd_1
XTAP_TAPCELL_ROW_32_193 _unconnected_494 _unconnected_495
+ sky130_fd_sc_hd__tapvpwrvgnd_1
XTAP_TAPCELL_ROW_32_194 _unconnected_496 _unconnected_497
+ sky130_fd_sc_hd__tapvpwrvgnd_1
XTAP_TAPCELL_ROW_32_195 _unconnected_498 _unconnected_499
+ sky130_fd_sc_hd__tapvpwrvgnd_1
XTAP_TAPCELL_ROW_32_196 _unconnected_500 _unconnected_501
+ sky130_fd_sc_hd__tapvpwrvgnd_1
XTAP_TAPCELL_ROW_33_197 _unconnected_502 _unconnected_503
+ sky130_fd_sc_hd__tapvpwrvgnd_1
XTAP_TAPCELL_ROW_33_198 _unconnected_504 _unconnected_505
+ sky130_fd_sc_hd__tapvpwrvgnd_1
XTAP_TAPCELL_ROW_33_199 _unconnected_506 _unconnected_507
+ sky130_fd_sc_hd__tapvpwrvgnd_1
XTAP_TAPCELL_ROW_34_200 _unconnected_508 _unconnected_509
+ sky130_fd_sc_hd__tapvpwrvgnd_1
XTAP_TAPCELL_ROW_34_201 _unconnected_510 _unconnected_511
+ sky130_fd_sc_hd__tapvpwrvgnd_1
XTAP_TAPCELL_ROW_34_202 _unconnected_512 _unconnected_513
+ sky130_fd_sc_hd__tapvpwrvgnd_1
XTAP_TAPCELL_ROW_34_203 _unconnected_514 _unconnected_515
+ sky130_fd_sc_hd__tapvpwrvgnd_1
XTAP_TAPCELL_ROW_35_204 _unconnected_516 _unconnected_517
+ sky130_fd_sc_hd__tapvpwrvgnd_1
XTAP_TAPCELL_ROW_35_205 _unconnected_518 _unconnected_519
+ sky130_fd_sc_hd__tapvpwrvgnd_1
XTAP_TAPCELL_ROW_35_206 _unconnected_520 _unconnected_521
+ sky130_fd_sc_hd__tapvpwrvgnd_1
XTAP_TAPCELL_ROW_36_207 _unconnected_522 _unconnected_523
+ sky130_fd_sc_hd__tapvpwrvgnd_1
XTAP_TAPCELL_ROW_36_208 _unconnected_524 _unconnected_525
+ sky130_fd_sc_hd__tapvpwrvgnd_1
XTAP_TAPCELL_ROW_36_209 _unconnected_526 _unconnected_527
+ sky130_fd_sc_hd__tapvpwrvgnd_1
XTAP_TAPCELL_ROW_36_210 _unconnected_528 _unconnected_529
+ sky130_fd_sc_hd__tapvpwrvgnd_1
XTAP_TAPCELL_ROW_37_211 _unconnected_530 _unconnected_531
+ sky130_fd_sc_hd__tapvpwrvgnd_1
XTAP_TAPCELL_ROW_37_212 _unconnected_532 _unconnected_533
+ sky130_fd_sc_hd__tapvpwrvgnd_1
XTAP_TAPCELL_ROW_37_213 _unconnected_534 _unconnected_535
+ sky130_fd_sc_hd__tapvpwrvgnd_1
XTAP_TAPCELL_ROW_38_214 _unconnected_536 _unconnected_537
+ sky130_fd_sc_hd__tapvpwrvgnd_1
XTAP_TAPCELL_ROW_38_215 _unconnected_538 _unconnected_539
+ sky130_fd_sc_hd__tapvpwrvgnd_1
XTAP_TAPCELL_ROW_38_216 _unconnected_540 _unconnected_541
+ sky130_fd_sc_hd__tapvpwrvgnd_1
XTAP_TAPCELL_ROW_38_217 _unconnected_542 _unconnected_543
+ sky130_fd_sc_hd__tapvpwrvgnd_1
XTAP_TAPCELL_ROW_38_218 _unconnected_544 _unconnected_545
+ sky130_fd_sc_hd__tapvpwrvgnd_1
XTAP_TAPCELL_ROW_38_219 _unconnected_546 _unconnected_547
+ sky130_fd_sc_hd__tapvpwrvgnd_1
XTAP_TAPCELL_ROW_38_220 _unconnected_548 _unconnected_549
+ sky130_fd_sc_hd__tapvpwrvgnd_1
XTAP_TAPCELL_ROW_3_92 _unconnected_550 _unconnected_551 sky130_fd_sc_hd__tapvpwrvgnd_1
XTAP_TAPCELL_ROW_3_93 _unconnected_552 _unconnected_553 sky130_fd_sc_hd__tapvpwrvgnd_1
XTAP_TAPCELL_ROW_3_94 _unconnected_554 _unconnected_555 sky130_fd_sc_hd__tapvpwrvgnd_1
XTAP_TAPCELL_ROW_4_95 _unconnected_556 _unconnected_557 sky130_fd_sc_hd__tapvpwrvgnd_1
XTAP_TAPCELL_ROW_4_96 _unconnected_558 _unconnected_559 sky130_fd_sc_hd__tapvpwrvgnd_1
XTAP_TAPCELL_ROW_4_97 _unconnected_560 _unconnected_561 sky130_fd_sc_hd__tapvpwrvgnd_1
XTAP_TAPCELL_ROW_4_98 _unconnected_562 _unconnected_563 sky130_fd_sc_hd__tapvpwrvgnd_1
XTAP_TAPCELL_ROW_5_100 _unconnected_564 _unconnected_565 sky130_fd_sc_hd__tapvpwrvgnd_1
XTAP_TAPCELL_ROW_5_101 _unconnected_566 _unconnected_567 sky130_fd_sc_hd__tapvpwrvgnd_1
XTAP_TAPCELL_ROW_5_99 _unconnected_568 _unconnected_569 sky130_fd_sc_hd__tapvpwrvgnd_1
XTAP_TAPCELL_ROW_6_102 _unconnected_570 _unconnected_571 sky130_fd_sc_hd__tapvpwrvgnd_1
XTAP_TAPCELL_ROW_6_103 _unconnected_572 _unconnected_573 sky130_fd_sc_hd__tapvpwrvgnd_1
XTAP_TAPCELL_ROW_6_104 _unconnected_574 _unconnected_575 sky130_fd_sc_hd__tapvpwrvgnd_1
XTAP_TAPCELL_ROW_6_105 _unconnected_576 _unconnected_577 sky130_fd_sc_hd__tapvpwrvgnd_1
XTAP_TAPCELL_ROW_7_106 _unconnected_578 _unconnected_579 sky130_fd_sc_hd__tapvpwrvgnd_1
XTAP_TAPCELL_ROW_7_107 _unconnected_580 _unconnected_581 sky130_fd_sc_hd__tapvpwrvgnd_1
XTAP_TAPCELL_ROW_7_108 _unconnected_582 _unconnected_583 sky130_fd_sc_hd__tapvpwrvgnd_1
XTAP_TAPCELL_ROW_8_109 _unconnected_584 _unconnected_585 sky130_fd_sc_hd__tapvpwrvgnd_1
XTAP_TAPCELL_ROW_8_110 _unconnected_586 _unconnected_587 sky130_fd_sc_hd__tapvpwrvgnd_1
XTAP_TAPCELL_ROW_8_111 _unconnected_588 _unconnected_589 sky130_fd_sc_hd__tapvpwrvgnd_1
XTAP_TAPCELL_ROW_8_112 _unconnected_590 _unconnected_591 sky130_fd_sc_hd__tapvpwrvgnd_1
XTAP_TAPCELL_ROW_9_113 _unconnected_592 _unconnected_593 sky130_fd_sc_hd__tapvpwrvgnd_1
XTAP_TAPCELL_ROW_9_114 _unconnected_594 _unconnected_595 sky130_fd_sc_hd__tapvpwrvgnd_1
XTAP_TAPCELL_ROW_9_115 _unconnected_596 _unconnected_597 sky130_fd_sc_hd__tapvpwrvgnd_1
X_161_ rd_ptr[0] wr_ptr[0] VSS _unconnected_598 _unconnected_599
+ VDD _45_ sky130_fd_sc_hd__xor2_1
X_162_ rd_ptr[1] wr_ptr[1] VSS _unconnected_600 _unconnected_601
+ VDD _46_ sky130_fd_sc_hd__xor2_1
X_163_ rd_ptr[3] wr_ptr[3] VSS _unconnected_602 _unconnected_603
+ VDD _47_ sky130_fd_sc_hd__xor2_1
X_164_ wr_ptr[2] rd_ptr[2] VSS _unconnected_604 _unconnected_605
+ VDD _48_ sky130_fd_sc_hd__xor2_1
X_165_ _45_ _46_ _47_ _48_ VSS _unconnected_606 _unconnected_607
+ VDD _49_ sky130_fd_sc_hd__nor4_1
X_166_ rd_ptr[4] wr_ptr[4] VSS _unconnected_608 _unconnected_609
+ VDD _50_ sky130_fd_sc_hd__xnor2_1
X_167_ rd_ptr[4] wr_ptr[4] VSS _unconnected_610 _unconnected_611
+ VDD _51_ sky130_fd_sc_hd__xor2_1
X_168_ _49_ _50_ VSS _unconnected_612 _unconnected_613 VDD
+ empty sky130_fd_sc_hd__and2_0
X_169_ _49_ _50_ rd_en VSS _unconnected_614 _unconnected_615
+ VDD _52_ sky130_fd_sc_hd__a21boi_0
X_170_ dout[6] net29 VSS _unconnected_616 _unconnected_617
+ VDD _53_ sky130_fd_sc_hd__nor2_1
X_171_ rd_ptr[1] rd_ptr[0] rd_ptr[3] rd_ptr[2] VSS _unconnected_618
+ _unconnected_619 VDD _54_ sky130_fd_sc_hd__nor4bb_1
X_172_ rd_ptr[1] rd_ptr[0] rd_ptr[2] rd_ptr[3] VSS _unconnected_620
+ _unconnected_621 VDD _55_ sky130_fd_sc_hd__nor4b_1
X_173_ rd_ptr[1] rd_ptr[2] rd_ptr[3] rd_ptr[0] VSS _unconnected_622
+ _unconnected_623 VDD _56_ sky130_fd_sc_hd__nor4bb_1
X_174_ rd_ptr[0] rd_ptr[3] rd_ptr[2] rd_ptr[1] VSS _unconnected_624
+ _unconnected_625 VDD _57_ sky130_fd_sc_hd__and4b_1
X_175_ rd_ptr[3] rd_ptr[2] rd_ptr[1] rd_ptr[0] VSS _unconnected_626
+ _unconnected_627 VDD _58_ sky130_fd_sc_hd__nor4bb_1
X_176_ mem\[3\][6] net36 VSS _unconnected_628 _unconnected_629
+ VDD _59_ sky130_fd_sc_hd__nand2_1
X_177_ rd_ptr[1] rd_ptr[0] rd_ptr[3] rd_ptr[2] VSS _unconnected_630
+ _unconnected_631 VDD _60_ sky130_fd_sc_hd__and4b_1
X_178_ rd_ptr[1] rd_ptr[0] rd_ptr[3] rd_ptr[2] VSS _unconnected_632
+ _unconnected_633 VDD _61_ sky130_fd_sc_hd__nor4b_1
X_179_ rd_ptr[0] rd_ptr[3] rd_ptr[2] rd_ptr[1] VSS _unconnected_634
+ _unconnected_635 VDD _62_ sky130_fd_sc_hd__nor4b_1
X_180_ rd_ptr[0] rd_ptr[3] rd_ptr[2] rd_ptr[1] VSS _unconnected_636
+ _unconnected_637 VDD _63_ sky130_fd_sc_hd__nor4bb_1
X_181_ rd_ptr[1] rd_ptr[3] rd_ptr[2] rd_ptr[0] VSS _unconnected_638
+ _unconnected_639 VDD _64_ sky130_fd_sc_hd__nor4bb_1
X_182_ rd_ptr[2] rd_ptr[3] rd_ptr[0] rd_ptr[1] VSS _unconnected_640
+ _unconnected_641 VDD _65_ sky130_fd_sc_hd__and4b_1
X_183_ rd_ptr[0] rd_ptr[2] rd_ptr[3] rd_ptr[1] VSS _unconnected_642
+ _unconnected_643 VDD _66_ sky130_fd_sc_hd__nor4bb_1
X_184_ rd_ptr[1] rd_ptr[0] rd_ptr[3] rd_ptr[2] VSS _unconnected_644
+ _unconnected_645 VDD _67_ sky130_fd_sc_hd__and4_1
X_185_ rd_ptr[1] rd_ptr[0] rd_ptr[3] rd_ptr[2] VSS _unconnected_646
+ _unconnected_647 VDD _68_ sky130_fd_sc_hd__nor4_2
X_186_ rd_ptr[3] rd_ptr[2] rd_ptr[1] rd_ptr[0] VSS _unconnected_648
+ _unconnected_649 VDD _69_ sky130_fd_sc_hd__and4b_1
X_187_ rd_ptr[1] rd_ptr[3] rd_ptr[2] rd_ptr[0] VSS _unconnected_650
+ _unconnected_651 VDD _70_ sky130_fd_sc_hd__nor4b_1
X_188_ mem\[12\][6] net39 net34 mem\[2\][6] _68_ net43 VSS
+ _unconnected_652 _unconnected_653 VDD _71_ sky130_fd_sc_hd__a222oi_1
X_189_ mem\[8\][6] net38 net35 mem\[4\][6] VSS _unconnected_654
+ _unconnected_655 VDD _72_ sky130_fd_sc_hd__a22oi_1
X_190_ mem\[9\][6] net37 _67_ mem\[15\][6] _60_ mem\[13\][6]
+ VSS _unconnected_656 _unconnected_657 VDD _73_ sky130_fd_sc_hd__a222oi_1
X_191_ mem\[5\][6] net32 net30 mem\[1\][6] VSS _unconnected_658
+ _unconnected_659 VDD _74_ sky130_fd_sc_hd__a22o_1
X_192_ mem\[6\][6] net33 _69_ mem\[7\][6] _74_ VSS _unconnected_660
+ _unconnected_661 VDD _75_ sky130_fd_sc_hd__a221oi_1
X_193_ mem\[14\][6] _57_ _65_ mem\[11\][6] net31 mem\[10\][6]
+ VSS _unconnected_662 _unconnected_663 VDD _76_ sky130_fd_sc_hd__a222oi_1
X_194_ _59_ _73_ _75_ _76_ VSS _unconnected_664 _unconnected_665
+ VDD _77_ sky130_fd_sc_hd__and4_1
X_195_ net29 net44 _72_ _77_ _53_ VSS _unconnected_666 _unconnected_667
+ VDD _11_ sky130_fd_sc_hd__a41oi_1
X_196_ dout[5] net29 VSS _unconnected_668 _unconnected_669
+ VDD _78_ sky130_fd_sc_hd__nor2_1
X_197_ net46 net38 VSS _unconnected_670 _unconnected_671 VDD
+ _79_ sky130_fd_sc_hd__nand2_1
X_198_ mem\[2\][5] net34 _68_ mem\[0\][5] net31 mem\[10\][5]
+ VSS _unconnected_672 _unconnected_673 VDD _80_ sky130_fd_sc_hd__a222oi_1
X_199_ _79_ _80_ VSS _unconnected_674 _unconnected_675 VDD
+ _81_ sky130_fd_sc_hd__nand2_1
X_200_ mem\[6\][5] net33 net32 mem\[5\][5] net30 mem\[1\][5]
+ VSS _unconnected_676 _unconnected_677 VDD _82_ sky130_fd_sc_hd__a222oi_1
X_201_ mem\[14\][5] _57_ _60_ mem\[13\][5] net35 mem\[4\][5]
+ VSS _unconnected_678 _unconnected_679 VDD _83_ sky130_fd_sc_hd__a222oi_1
X_202_ mem\[12\][5] net39 _69_ mem\[7\][5] _67_ mem\[15\][5]
+ VSS _unconnected_680 _unconnected_681 VDD _84_ sky130_fd_sc_hd__a222oi_1
X_203_ mem\[9\][5] net37 net36 mem\[3\][5] _65_ mem\[11\][5]
+ VSS _unconnected_682 _unconnected_683 VDD _85_ sky130_fd_sc_hd__a222oi_1
X_204_ _82_ _83_ _84_ _85_ VSS _unconnected_684 _unconnected_685
+ VDD _86_ sky130_fd_sc_hd__nand4_1
X_205_ net47 _86_ VSS _unconnected_686 _unconnected_687 VDD
+ _87_ sky130_fd_sc_hd__nor2_1
X_206_ net29 net48 _78_ VSS _unconnected_688 _unconnected_689
+ VDD _44_ sky130_fd_sc_hd__a21oi_1
X_207_ dout[4] net29 VSS _unconnected_690 _unconnected_691
+ VDD _88_ sky130_fd_sc_hd__nor2_1
X_208_ mem\[15\][4] _67_ VSS _unconnected_692 _unconnected_693
+ VDD _89_ sky130_fd_sc_hd__nand2_1
X_209_ mem\[6\][4] net33 _68_ mem\[0\][4] _69_ mem\[7\][4]
+ VSS _unconnected_694 _unconnected_695 VDD _90_ sky130_fd_sc_hd__a222oi_1
X_210_ mem\[3\][4] net36 net30 mem\[1\][4] net32 mem\[5\][4]
+ VSS _unconnected_696 _unconnected_697 VDD _91_ sky130_fd_sc_hd__a222oi_1
X_211_ mem\[14\][4] _57_ net34 mem\[2\][4] VSS _unconnected_698
+ _unconnected_699 VDD _92_ sky130_fd_sc_hd__a22oi_1
X_212_ _90_ _91_ _92_ VSS _unconnected_700 _unconnected_701
+ VDD _93_ sky130_fd_sc_hd__nand3_1
X_213_ mem\[13\][4] _60_ net35 mem\[4\][4] net31 mem\[10\][4]
+ VSS _unconnected_702 _unconnected_703 VDD _94_ sky130_fd_sc_hd__a222oi_1
X_214_ net58 net38 _65_ mem\[11\][4] VSS _unconnected_704
+ _unconnected_705 VDD _95_ sky130_fd_sc_hd__a22oi_1
X_215_ mem\[12\][4] net39 net37 mem\[9\][4] VSS _unconnected_706
+ _unconnected_707 VDD _96_ sky130_fd_sc_hd__a22oi_1
X_216_ _89_ _94_ _95_ _96_ VSS _unconnected_708 _unconnected_709
+ VDD _97_ sky130_fd_sc_hd__nand4_1
X_217_ _93_ net59 VSS _unconnected_710 _unconnected_711 VDD
+ _98_ sky130_fd_sc_hd__nor2_1
X_218_ net29 net60 _88_ VSS _unconnected_712 _unconnected_713
+ VDD _42_ sky130_fd_sc_hd__a21oi_1
X_219_ mem\[3\][3] net36 net35 mem\[4\][3] VSS _unconnected_714
+ _unconnected_715 VDD _99_ sky130_fd_sc_hd__a22oi_1
X_220_ net40 net38 VSS _unconnected_716 _unconnected_717 VDD
+ _100_ sky130_fd_sc_hd__nand2_1
X_221_ mem\[12\][3] net39 net37 mem\[9\][3] VSS _unconnected_718
+ _unconnected_719 VDD _101_ sky130_fd_sc_hd__a22oi_1
X_222_ mem\[11\][3] _65_ net31 mem\[10\][3] VSS _unconnected_720
+ _unconnected_721 VDD _102_ sky130_fd_sc_hd__a22oi_1
X_223_ mem\[5\][3] net32 _68_ mem\[0\][3] net30 mem\[1\][3]
+ VSS _unconnected_722 _unconnected_723 VDD _103_ sky130_fd_sc_hd__a222oi_1
X_224_ _99_ _103_ VSS _unconnected_724 _unconnected_725 VDD
+ _104_ sky130_fd_sc_hd__nand2_1
X_225_ _100_ _101_ _102_ VSS _unconnected_726 _unconnected_727
+ VDD _105_ sky130_fd_sc_hd__nand3_1
X_226_ mem\[13\][3] _60_ net34 mem\[2\][3] _69_ mem\[7\][3]
+ VSS _unconnected_728 _unconnected_729 VDD _106_ sky130_fd_sc_hd__a222oi_1
X_227_ mem\[14\][3] _57_ net33 mem\[6\][3] _67_ mem\[15\][3]
+ VSS _unconnected_730 _unconnected_731 VDD _107_ sky130_fd_sc_hd__a222oi_1
X_228_ net29 _106_ _107_ VSS _unconnected_732 _unconnected_733
+ VDD _108_ sky130_fd_sc_hd__nand3_1
X_229_ _104_ net41 _108_ net29 dout[3] VSS _unconnected_734
+ _unconnected_735 VDD _12_ sky130_fd_sc_hd__o32a_1
X_230_ dout[2] net29 VSS _unconnected_736 _unconnected_737
+ VDD _109_ sky130_fd_sc_hd__nor2_1
X_231_ net49 net35 VSS _unconnected_738 _unconnected_739 VDD
+ _110_ sky130_fd_sc_hd__nand2_1
X_232_ mem\[2\][2] net34 net33 mem\[6\][2] mem\[7\][2] _69_
+ VSS _unconnected_740 _unconnected_741 VDD _111_ sky130_fd_sc_hd__a222oi_1
X_233_ mem\[12\][2] net39 _57_ mem\[14\][2] mem\[15\][2] _67_
+ VSS _unconnected_742 _unconnected_743 VDD _112_ sky130_fd_sc_hd__a222oi_1
X_234_ mem\[8\][2] net38 net32 mem\[5\][2] VSS _unconnected_744
+ _unconnected_745 VDD _113_ sky130_fd_sc_hd__a22oi_1
X_235_ _111_ _112_ _113_ VSS _unconnected_746 _unconnected_747
+ VDD _114_ sky130_fd_sc_hd__nand3_1
X_236_ mem\[3\][2] net36 net30 mem\[1\][2] _60_ mem\[13\][2]
+ VSS _unconnected_748 _unconnected_749 VDD _115_ sky130_fd_sc_hd__a222oi_1
X_237_ mem\[10\][2] net31 _68_ mem\[0\][2] VSS _unconnected_750
+ _unconnected_751 VDD _116_ sky130_fd_sc_hd__a22oi_1
X_238_ mem\[9\][2] net37 _65_ mem\[11\][2] VSS _unconnected_752
+ _unconnected_753 VDD _117_ sky130_fd_sc_hd__a22oi_1
X_239_ _110_ _115_ _116_ _117_ VSS _unconnected_754 _unconnected_755
+ VDD _118_ sky130_fd_sc_hd__nand4_1
X_240_ _114_ net50 VSS _unconnected_756 _unconnected_757 VDD
+ _119_ sky130_fd_sc_hd__nor2_1
X_241_ net29 net51 _109_ VSS _unconnected_758 _unconnected_759
+ VDD _13_ sky130_fd_sc_hd__a21oi_1
X_242_ dout[1] net29 VSS _unconnected_760 _unconnected_761
+ VDD _120_ sky130_fd_sc_hd__nor2_1
X_243_ mem\[9\][1] net37 VSS _unconnected_762 _unconnected_763
+ VDD _121_ sky130_fd_sc_hd__nand2_1
X_244_ mem\[14\][1] _57_ net33 mem\[6\][1] net30 mem\[1\][1]
+ VSS _unconnected_764 _unconnected_765 VDD _122_ sky130_fd_sc_hd__a222oi_1
X_245_ mem\[4\][1] net35 net34 mem\[2\][1] _69_ mem\[7\][1]
+ VSS _unconnected_766 _unconnected_767 VDD _123_ sky130_fd_sc_hd__a222oi_1
X_246_ mem\[3\][1] net36 _68_ mem\[0\][1] VSS _unconnected_768
+ _unconnected_769 VDD _124_ sky130_fd_sc_hd__a22oi_1
X_247_ _122_ _123_ _124_ VSS _unconnected_770 _unconnected_771
+ VDD _125_ sky130_fd_sc_hd__nand3_1
X_248_ mem\[13\][1] _60_ net32 mem\[5\][1] _65_ mem\[11\][1]
+ VSS _unconnected_772 _unconnected_773 VDD _126_ sky130_fd_sc_hd__a222oi_1
X_249_ mem\[10\][1] net31 _67_ mem\[15\][1] VSS _unconnected_774
+ _unconnected_775 VDD _127_ sky130_fd_sc_hd__a22oi_1
X_250_ mem\[12\][1] net39 net38 net61 VSS _unconnected_776
+ _unconnected_777 VDD _128_ sky130_fd_sc_hd__a22oi_1
X_251_ _121_ _126_ _127_ _128_ VSS _unconnected_778 _unconnected_779
+ VDD _129_ sky130_fd_sc_hd__nand4_1
X_252_ _125_ net62 VSS _unconnected_780 _unconnected_781 VDD
+ _130_ sky130_fd_sc_hd__nor2_1
X_253_ net29 net63 _120_ VSS _unconnected_782 _unconnected_783
+ VDD _14_ sky130_fd_sc_hd__a21oi_1
X_254_ dout[0] net29 VSS _unconnected_784 _unconnected_785
+ VDD _131_ sky130_fd_sc_hd__nor2_1
X_255_ mem\[10\][0] net31 VSS _unconnected_786 _unconnected_787
+ VDD _132_ sky130_fd_sc_hd__nand2_1
X_256_ net55 net33 VSS _unconnected_788 _unconnected_789 VDD
+ _133_ sky130_fd_sc_hd__nand2_1
X_257_ mem\[3\][0] net36 net32 mem\[5\][0] mem\[15\][0] _67_
+ VSS _unconnected_790 _unconnected_791 VDD _134_ sky130_fd_sc_hd__a222oi_1
X_258_ mem\[14\][0] _57_ net35 mem\[4\][0] VSS _unconnected_792
+ _unconnected_793 VDD _135_ sky130_fd_sc_hd__a22oi_1
X_259_ mem\[8\][0] net38 _65_ mem\[11\][0] VSS _unconnected_794
+ _unconnected_795 VDD _136_ sky130_fd_sc_hd__a22oi_1
X_260_ _133_ _134_ _135_ _136_ VSS _unconnected_796 _unconnected_797
+ VDD _137_ sky130_fd_sc_hd__nand4_1
X_261_ mem\[12\][0] net39 _69_ mem\[7\][0] net37 mem\[9\][0]
+ VSS _unconnected_798 _unconnected_799 VDD _138_ sky130_fd_sc_hd__a222oi_1
X_262_ mem\[0\][0] _68_ net30 mem\[1\][0] VSS _unconnected_800
+ _unconnected_801 VDD _139_ sky130_fd_sc_hd__a22oi_1
X_263_ mem\[13\][0] _60_ net34 mem\[2\][0] VSS _unconnected_802
+ _unconnected_803 VDD _140_ sky130_fd_sc_hd__a22oi_1
X_264_ _132_ _138_ _139_ _140_ VSS _unconnected_804 _unconnected_805
+ VDD _141_ sky130_fd_sc_hd__nand4_1
X_265_ net56 _141_ VSS _unconnected_806 _unconnected_807 VDD
+ _142_ sky130_fd_sc_hd__nor2_1
X_266_ net29 net57 _131_ VSS _unconnected_808 _unconnected_809
+ VDD _15_ sky130_fd_sc_hd__a21oi_1
X_267_ rd_ptr[1] rd_ptr[0] net29 VSS _unconnected_810 _unconnected_811
+ VDD _143_ sky130_fd_sc_hd__nand3_1
X_268_ rd_ptr[1] rd_ptr[0] rd_ptr[2] net29 rd_ptr[3] VSS _unconnected_812
+ _unconnected_813 VDD _144_ sky130_fd_sc_hd__a41oi_1
X_269_ net29 _67_ VSS _unconnected_814 _unconnected_815 VDD
+ _145_ sky130_fd_sc_hd__nand2_1
X_270_ net29 _67_ _144_ VSS _unconnected_816 _unconnected_817
+ VDD _16_ sky130_fd_sc_hd__a21oi_1
X_271_ rd_ptr[2] _143_ VSS _unconnected_818 _unconnected_819
+ VDD _17_ sky130_fd_sc_hd__xnor2_1
X_272_ rd_ptr[0] net29 rd_ptr[1] VSS _unconnected_820 _unconnected_821
+ VDD _146_ sky130_fd_sc_hd__a21oi_1
X_273_ _143_ _146_ VSS _unconnected_822 _unconnected_823 VDD
+ _18_ sky130_fd_sc_hd__lpflow_isobufsrc_1
X_274_ rd_ptr[0] net29 VSS _unconnected_824 _unconnected_825
+ VDD _19_ sky130_fd_sc_hd__xor2_1
X_275_ _49_ _51_ VSS _unconnected_826 _unconnected_827 VDD
+ full sky130_fd_sc_hd__and2_0
X_276_ _49_ _51_ wr_en VSS _unconnected_828 _unconnected_829
+ VDD _147_ sky130_fd_sc_hd__a21boi_0
X_277_ wr_ptr[0] net28 VSS _unconnected_830 _unconnected_831
+ VDD _148_ sky130_fd_sc_hd__nand2_1
X_278_ wr_ptr[1] wr_ptr[0] VSS _unconnected_832 _unconnected_833
+ VDD _149_ sky130_fd_sc_hd__nand2_1
X_279_ wr_ptr[2] wr_ptr[3] VSS _unconnected_834 _unconnected_835
+ VDD _150_ sky130_fd_sc_hd__nand2_1
X_280_ _150_ VSS _unconnected_836 _unconnected_837 VDD _151_
+ sky130_fd_sc_hd__clkinv_1
X_281_ wr_ptr[2] net64 net66 net28 VSS _unconnected_838 _unconnected_839
+ VDD _152_ sky130_fd_sc_hd__nand4_1
X_282_ wr_ptr[1] wr_ptr[0] net28 _151_ VSS _unconnected_840
+ _unconnected_841 VDD _153_ sky130_fd_sc_hd__nand4_1
X_283_ wr_ptr[3] _152_ VSS _unconnected_842 _unconnected_843
+ VDD _20_ sky130_fd_sc_hd__xnor2_1
X_284_ net64 wr_ptr[0] net28 wr_ptr[2] VSS _unconnected_844
+ _unconnected_845 VDD _154_ sky130_fd_sc_hd__a31oi_1
X_285_ _152_ net65 VSS _unconnected_846 _unconnected_847 VDD
+ _21_ sky130_fd_sc_hd__lpflow_isobufsrc_1
X_286_ wr_ptr[1] _148_ VSS _unconnected_848 _unconnected_849
+ VDD _22_ sky130_fd_sc_hd__xnor2_1
X_287_ wr_ptr[0] net28 VSS _unconnected_850 _unconnected_851
+ VDD _23_ sky130_fd_sc_hd__xor2_1
X_288_ dout[7] net29 VSS _unconnected_852 _unconnected_853
+ VDD _155_ sky130_fd_sc_hd__nor2_1
X_289_ net52 net36 VSS _unconnected_854 _unconnected_855 VDD
+ _156_ sky130_fd_sc_hd__nand2_1
X_290_ mem\[13\][7] _60_ net32 mem\[5\][7] VSS _unconnected_856
+ _unconnected_857 VDD _157_ sky130_fd_sc_hd__a22oi_1
X_291_ mem\[12\][7] net39 net38 mem\[8\][7] _67_ mem\[15\][7]
+ VSS _unconnected_858 _unconnected_859 VDD _158_ sky130_fd_sc_hd__a222oi_1
X_292_ mem\[6\][7] net33 _68_ mem\[0\][7] _69_ mem\[7\][7]
+ VSS _unconnected_860 _unconnected_861 VDD _159_ sky130_fd_sc_hd__a222oi_1
X_293_ _156_ _158_ _159_ VSS _unconnected_862 _unconnected_863
+ VDD _160_ sky130_fd_sc_hd__nand3_1
X_294_ mem\[14\][7] _57_ net34 mem\[2\][7] VSS _unconnected_864
+ _unconnected_865 VDD _0_ sky130_fd_sc_hd__a22oi_1
X_295_ mem\[4\][7] net35 net30 mem\[1\][7] VSS _unconnected_866
+ _unconnected_867 VDD _1_ sky130_fd_sc_hd__a22oi_1
X_296_ mem\[11\][7] _65_ net31 mem\[10\][7] mem\[9\][7] net37
+ VSS _unconnected_868 _unconnected_869 VDD _2_ sky130_fd_sc_hd__a222oi_1
X_297_ _157_ _0_ _1_ _2_ VSS _unconnected_870 _unconnected_871
+ VDD _3_ sky130_fd_sc_hd__nand4_1
X_298_ net53 _3_ VSS _unconnected_872 _unconnected_873 VDD
+ _4_ sky130_fd_sc_hd__nor2_1
X_299_ net29 net54 _155_ VSS _unconnected_874 _unconnected_875
+ VDD _24_ sky130_fd_sc_hd__a21oi_1
X_300_ wr_ptr[2] wr_ptr[3] VSS _unconnected_876 _unconnected_877
+ VDD _5_ sky130_fd_sc_hd__lpflow_inputiso1p_1
X_301_ rst _147_ VSS _unconnected_878 _unconnected_879 VDD
+ _6_ sky130_fd_sc_hd__nand2_1
X_302_ wr_ptr[0] rst net28 wr_ptr[1] VSS _unconnected_880
+ _unconnected_881 VDD _7_ sky130_fd_sc_hd__nand4b_1
X_303_ _5_ _7_ VSS _unconnected_882 _unconnected_883 VDD _25_
+ sky130_fd_sc_hd__nor2_1
X_304_ wr_ptr[2] wr_ptr[3] VSS _unconnected_884 _unconnected_885
+ VDD _8_ sky130_fd_sc_hd__nand2b_1
X_305_ wr_ptr[1] wr_ptr[0] _6_ _8_ VSS _unconnected_886 _unconnected_887
+ VDD _26_ sky130_fd_sc_hd__nor4_1
X_306_ rd_ptr[4] _145_ VSS _unconnected_888 _unconnected_889
+ VDD _27_ sky130_fd_sc_hd__xnor2_1
X_307_ wr_ptr[4] _153_ VSS _unconnected_890 _unconnected_891
+ VDD _28_ sky130_fd_sc_hd__xnor2_1
X_308_ _149_ _6_ _8_ VSS _unconnected_892 _unconnected_893
+ VDD _29_ sky130_fd_sc_hd__nor3_1
X_309_ _7_ _8_ VSS _unconnected_894 _unconnected_895 VDD _30_
+ sky130_fd_sc_hd__nor2_1
X_310_ wr_ptr[1] wr_ptr[0] rst net28 VSS _unconnected_896
+ _unconnected_897 VDD _9_ sky130_fd_sc_hd__nand4b_1
X_311_ _5_ _9_ VSS _unconnected_898 _unconnected_899 VDD _31_
+ sky130_fd_sc_hd__nor2_1
X_312_ _149_ _150_ _6_ VSS _unconnected_900 _unconnected_901
+ VDD _32_ sky130_fd_sc_hd__nor3_1
X_313_ wr_ptr[3] wr_ptr[2] VSS _unconnected_902 _unconnected_903
+ VDD _10_ sky130_fd_sc_hd__nand2b_1
X_314_ _149_ _6_ _10_ VSS _unconnected_904 _unconnected_905
+ VDD _33_ sky130_fd_sc_hd__nor3_1
X_315_ wr_ptr[1] wr_ptr[0] _150_ _6_ VSS _unconnected_906
+ _unconnected_907 VDD _34_ sky130_fd_sc_hd__nor4_1
X_316_ _9_ _10_ VSS _unconnected_908 _unconnected_909 VDD
+ _35_ sky130_fd_sc_hd__nor2_1
X_317_ _8_ _9_ VSS _unconnected_910 _unconnected_911 VDD _36_
+ sky130_fd_sc_hd__nor2_1
X_318_ wr_ptr[1] wr_ptr[0] _6_ _10_ VSS _unconnected_912 _unconnected_913
+ VDD _37_ sky130_fd_sc_hd__nor4_1
X_319_ _150_ _7_ VSS _unconnected_914 _unconnected_915 VDD
+ _38_ sky130_fd_sc_hd__nor2_1
X_320_ _7_ _10_ VSS _unconnected_916 _unconnected_917 VDD
+ _39_ sky130_fd_sc_hd__nor2_1
X_321_ wr_ptr[1] wr_ptr[0] _5_ _6_ VSS _unconnected_918 _unconnected_919
+ VDD _40_ sky130_fd_sc_hd__nor4_1
X_322_ _150_ _9_ VSS _unconnected_920 _unconnected_921 VDD
+ _41_ sky130_fd_sc_hd__nor2_1
X_323_ _149_ _5_ _6_ VSS _unconnected_922 _unconnected_923
+ VDD _43_ sky130_fd_sc_hd__nor3_1
X_324_ clknet_4_2_0_clk din[4] net25 VSS _unconnected_924
+ _unconnected_925 VDD mem\[7\][4] sky130_fd_sc_hd__edfxtp_1
X_325_ clknet_4_2_0_clk din[3] _33_ VSS _unconnected_926 _unconnected_927
+ VDD mem\[7\][3] sky130_fd_sc_hd__edfxtp_1
X_326_ clknet_4_2_0_clk din[2] net25 VSS _unconnected_928
+ _unconnected_929 VDD mem\[7\][2] sky130_fd_sc_hd__edfxtp_1
X_327_ clknet_4_13_0_clk din[4] _32_ VSS _unconnected_930
+ _unconnected_931 VDD mem\[15\][4] sky130_fd_sc_hd__edfxtp_1
X_328_ clknet_4_0_0_clk din[1] net25 VSS _unconnected_932
+ _unconnected_933 VDD mem\[7\][1] sky130_fd_sc_hd__edfxtp_1
X_329_ clknet_4_14_0_clk din[0] _33_ VSS _unconnected_934
+ _unconnected_935 VDD mem\[7\][0] sky130_fd_sc_hd__edfxtp_1
X_330_ clknet_4_12_0_clk din[6] net21 VSS _unconnected_936
+ _unconnected_937 VDD mem\[0\][6] sky130_fd_sc_hd__edfxtp_1
X_331_ clknet_4_4_0_clk din[5] net21 VSS _unconnected_938
+ _unconnected_939 VDD mem\[0\][5] sky130_fd_sc_hd__edfxtp_1
X_332_ clknet_4_2_0_clk din[4] net22 VSS _unconnected_940
+ _unconnected_941 VDD mem\[0\][4] sky130_fd_sc_hd__edfxtp_1
X_333_ clknet_4_8_0_clk din[3] net22 VSS _unconnected_942
+ _unconnected_943 VDD mem\[0\][3] sky130_fd_sc_hd__edfxtp_1
X_334_ clknet_4_12_0_clk din[2] net21 VSS _unconnected_944
+ _unconnected_945 VDD mem\[0\][2] sky130_fd_sc_hd__edfxtp_1
X_335_ clknet_4_3_0_clk din[3] _32_ VSS _unconnected_946 _unconnected_947
+ VDD mem\[15\][3] sky130_fd_sc_hd__edfxtp_1
X_336_ clknet_4_0_0_clk din[1] net22 VSS _unconnected_948
+ _unconnected_949 VDD mem\[0\][1] sky130_fd_sc_hd__edfxtp_1
X_337_ clknet_4_2_0_clk din[0] net22 VSS _unconnected_950
+ _unconnected_951 VDD mem\[0\][0] sky130_fd_sc_hd__edfxtp_1
X_338_ clknet_4_10_0_clk din[6] _31_ VSS _unconnected_952
+ _unconnected_953 VDD mem\[1\][6] sky130_fd_sc_hd__edfxtp_1
X_339_ clknet_4_10_0_clk din[5] _31_ VSS _unconnected_954
+ _unconnected_955 VDD mem\[1\][5] sky130_fd_sc_hd__edfxtp_1
X_340_ clknet_4_10_0_clk din[4] _31_ VSS _unconnected_956
+ _unconnected_957 VDD mem\[1\][4] sky130_fd_sc_hd__edfxtp_1
X_341_ clknet_4_8_0_clk din[3] _31_ VSS _unconnected_958 _unconnected_959
+ VDD mem\[1\][3] sky130_fd_sc_hd__edfxtp_1
X_342_ clknet_4_9_0_clk din[2] _31_ VSS _unconnected_960 _unconnected_961
+ VDD mem\[1\][2] sky130_fd_sc_hd__edfxtp_1
X_343_ clknet_4_6_0_clk din[2] _32_ VSS _unconnected_962 _unconnected_963
+ VDD mem\[15\][2] sky130_fd_sc_hd__edfxtp_1
X_344_ clknet_4_0_0_clk din[1] _31_ VSS _unconnected_964 _unconnected_965
+ VDD mem\[1\][1] sky130_fd_sc_hd__edfxtp_1
X_345_ clknet_4_3_0_clk din[0] _31_ VSS _unconnected_966 _unconnected_967
+ VDD mem\[1\][0] sky130_fd_sc_hd__edfxtp_1
X_346_ clknet_4_12_0_clk din[6] _25_ VSS _unconnected_968
+ _unconnected_969 VDD mem\[2\][6] sky130_fd_sc_hd__edfxtp_1
X_347_ clknet_4_3_0_clk din[5] _25_ VSS _unconnected_970 _unconnected_971
+ VDD mem\[2\][5] sky130_fd_sc_hd__edfxtp_1
X_348_ clknet_4_8_0_clk din[4] _25_ VSS _unconnected_972 _unconnected_973
+ VDD mem\[2\][4] sky130_fd_sc_hd__edfxtp_1
X_349_ clknet_4_2_0_clk din[3] _25_ VSS _unconnected_974 _unconnected_975
+ VDD mem\[2\][3] sky130_fd_sc_hd__edfxtp_1
X_350_ clknet_4_0_0_clk din[2] _25_ VSS _unconnected_976 _unconnected_977
+ VDD mem\[2\][2] sky130_fd_sc_hd__edfxtp_1
X_351_ clknet_4_4_0_clk _18_ rst VSS _unconnected_978 _unconnected_979
+ VDD rd_ptr[1] sky130_fd_sc_hd__dfrtp_1
X_352_ clknet_4_1_0_clk din[1] _25_ VSS _unconnected_980 _unconnected_981
+ VDD mem\[2\][1] sky130_fd_sc_hd__edfxtp_1
X_353_ clknet_4_3_0_clk din[0] _25_ VSS _unconnected_982 _unconnected_983
+ VDD mem\[2\][0] sky130_fd_sc_hd__edfxtp_1
X_354_ clknet_4_15_0_clk din[6] net27 VSS _unconnected_984
+ _unconnected_985 VDD mem\[8\][6] sky130_fd_sc_hd__edfxtp_1
X_355_ clknet_4_14_0_clk din[5] net27 VSS _unconnected_986
+ _unconnected_987 VDD mem\[8\][5] sky130_fd_sc_hd__edfxtp_1
X_356_ clknet_4_15_0_clk din[4] net27 VSS _unconnected_988
+ _unconnected_989 VDD mem\[8\][4] sky130_fd_sc_hd__edfxtp_1
X_357_ clknet_4_7_0_clk din[3] net27 VSS _unconnected_990
+ _unconnected_991 VDD mem\[8\][3] sky130_fd_sc_hd__edfxtp_1
X_358_ clknet_4_13_0_clk din[2] net27 VSS _unconnected_992
+ _unconnected_993 VDD mem\[8\][2] sky130_fd_sc_hd__edfxtp_1
X_359_ clknet_4_7_0_clk din[1] _32_ VSS _unconnected_994 _unconnected_995
+ VDD mem\[15\][1] sky130_fd_sc_hd__edfxtp_1
X_360_ clknet_4_4_0_clk din[1] net27 VSS _unconnected_996
+ _unconnected_997 VDD mem\[8\][1] sky130_fd_sc_hd__edfxtp_1
X_361_ clknet_4_12_0_clk din[0] net27 VSS _unconnected_998
+ _unconnected_999 VDD mem\[8\][0] sky130_fd_sc_hd__edfxtp_1
X_362_ clknet_4_12_0_clk din[6] net24 VSS _unconnected_1000
+ _unconnected_1001 VDD mem\[12\][6] sky130_fd_sc_hd__edfxtp_1
X_363_ clknet_4_14_0_clk din[5] net24 VSS _unconnected_1002
+ _unconnected_1003 VDD mem\[12\][5] sky130_fd_sc_hd__edfxtp_1
X_364_ clknet_4_15_0_clk din[4] net24 VSS _unconnected_1004
+ _unconnected_1005 VDD mem\[12\][4] sky130_fd_sc_hd__edfxtp_1
X_365_ clknet_4_7_0_clk din[3] net24 VSS _unconnected_1006
+ _unconnected_1007 VDD mem\[12\][3] sky130_fd_sc_hd__edfxtp_1
X_366_ clknet_4_7_0_clk din[2] net24 VSS _unconnected_1008
+ _unconnected_1009 VDD mem\[12\][2] sky130_fd_sc_hd__edfxtp_1
X_367_ clknet_4_11_0_clk din[0] _32_ VSS _unconnected_1010
+ _unconnected_1011 VDD mem\[15\][0] sky130_fd_sc_hd__edfxtp_1
X_368_ clknet_4_5_0_clk din[1] net24 VSS _unconnected_1012
+ _unconnected_1013 VDD mem\[12\][1] sky130_fd_sc_hd__edfxtp_1
X_369_ clknet_4_14_0_clk din[0] net24 VSS _unconnected_1014
+ _unconnected_1015 VDD mem\[12\][0] sky130_fd_sc_hd__edfxtp_1
X_370_ clknet_4_11_0_clk din[6] _43_ VSS _unconnected_1016
+ _unconnected_1017 VDD mem\[3\][6] sky130_fd_sc_hd__edfxtp_1
X_371_ clknet_4_11_0_clk din[5] _43_ VSS _unconnected_1018
+ _unconnected_1019 VDD mem\[3\][5] sky130_fd_sc_hd__edfxtp_1
X_372_ clknet_4_11_0_clk din[4] _43_ VSS _unconnected_1020
+ _unconnected_1021 VDD mem\[3\][4] sky130_fd_sc_hd__edfxtp_1
X_373_ clknet_4_11_0_clk din[3] _43_ VSS _unconnected_1022
+ _unconnected_1023 VDD mem\[3\][3] sky130_fd_sc_hd__edfxtp_1
X_374_ clknet_4_9_0_clk din[2] _43_ VSS _unconnected_1024
+ _unconnected_1025 VDD mem\[3\][2] sky130_fd_sc_hd__edfxtp_1
X_375_ clknet_4_10_0_clk din[6] _35_ VSS _unconnected_1026
+ _unconnected_1027 VDD mem\[5\][6] sky130_fd_sc_hd__edfxtp_1
X_376_ clknet_4_1_0_clk din[1] _43_ VSS _unconnected_1028
+ _unconnected_1029 VDD mem\[3\][1] sky130_fd_sc_hd__edfxtp_1
X_377_ clknet_4_11_0_clk din[0] _43_ VSS _unconnected_1030
+ _unconnected_1031 VDD mem\[3\][0] sky130_fd_sc_hd__edfxtp_1
X_378_ clknet_4_12_0_clk din[6] _30_ VSS _unconnected_1032
+ _unconnected_1033 VDD mem\[10\][6] sky130_fd_sc_hd__edfxtp_1
X_379_ clknet_4_6_0_clk din[5] _30_ VSS _unconnected_1034
+ _unconnected_1035 VDD mem\[10\][5] sky130_fd_sc_hd__edfxtp_1
X_380_ clknet_4_7_0_clk din[4] _30_ VSS _unconnected_1036
+ _unconnected_1037 VDD mem\[10\][4] sky130_fd_sc_hd__edfxtp_1
X_381_ clknet_4_7_0_clk din[3] _30_ VSS _unconnected_1038
+ _unconnected_1039 VDD mem\[10\][3] sky130_fd_sc_hd__edfxtp_1
X_382_ clknet_4_6_0_clk din[2] _30_ VSS _unconnected_1040
+ _unconnected_1041 VDD mem\[10\][2] sky130_fd_sc_hd__edfxtp_1
X_383_ clknet_4_10_0_clk din[5] _35_ VSS _unconnected_1042
+ _unconnected_1043 VDD mem\[5\][5] sky130_fd_sc_hd__edfxtp_1
X_384_ clknet_4_5_0_clk din[1] _30_ VSS _unconnected_1044
+ _unconnected_1045 VDD mem\[10\][1] sky130_fd_sc_hd__edfxtp_1
X_385_ clknet_4_6_0_clk din[0] _30_ VSS _unconnected_1046
+ _unconnected_1047 VDD mem\[10\][0] sky130_fd_sc_hd__edfxtp_1
X_386_ clknet_4_15_0_clk din[6] net23 VSS _unconnected_1048
+ _unconnected_1049 VDD mem\[4\][6] sky130_fd_sc_hd__edfxtp_1
X_387_ clknet_4_9_0_clk din[5] net23 VSS _unconnected_1050
+ _unconnected_1051 VDD mem\[4\][5] sky130_fd_sc_hd__edfxtp_1
X_388_ clknet_4_7_0_clk din[4] net23 VSS _unconnected_1052
+ _unconnected_1053 VDD mem\[4\][4] sky130_fd_sc_hd__edfxtp_1
X_389_ clknet_4_9_0_clk din[3] net23 VSS _unconnected_1054
+ _unconnected_1055 VDD mem\[4\][3] sky130_fd_sc_hd__edfxtp_1
X_390_ clknet_4_12_0_clk din[2] net23 VSS _unconnected_1056
+ _unconnected_1057 VDD mem\[4\][2] sky130_fd_sc_hd__edfxtp_1
X_391_ clknet_4_10_0_clk din[4] _35_ VSS _unconnected_1058
+ _unconnected_1059 VDD mem\[5\][4] sky130_fd_sc_hd__edfxtp_1
X_392_ clknet_4_8_0_clk din[3] _35_ VSS _unconnected_1060
+ _unconnected_1061 VDD mem\[5\][3] sky130_fd_sc_hd__edfxtp_1
X_393_ clknet_4_13_0_clk din[2] _35_ VSS _unconnected_1062
+ _unconnected_1063 VDD mem\[5\][2] sky130_fd_sc_hd__edfxtp_1
X_394_ clknet_4_4_0_clk _17_ rst VSS _unconnected_1064 _unconnected_1065
+ VDD rd_ptr[2] sky130_fd_sc_hd__dfrtp_1
X_395_ clknet_4_1_0_clk din[1] net23 VSS _unconnected_1066
+ _unconnected_1067 VDD mem\[4\][1] sky130_fd_sc_hd__edfxtp_1
X_396_ clknet_4_5_0_clk din[1] _35_ VSS _unconnected_1068
+ _unconnected_1069 VDD mem\[5\][1] sky130_fd_sc_hd__edfxtp_1
X_397_ clknet_4_9_0_clk din[0] net23 VSS _unconnected_1070
+ _unconnected_1071 VDD mem\[4\][0] sky130_fd_sc_hd__edfxtp_1
X_398_ clknet_4_11_0_clk din[0] _35_ VSS _unconnected_1072
+ _unconnected_1073 VDD mem\[5\][0] sky130_fd_sc_hd__edfxtp_1
X_399_ clknet_4_14_0_clk din[6] _36_ VSS _unconnected_1074
+ _unconnected_1075 VDD mem\[9\][6] sky130_fd_sc_hd__edfxtp_1
X_400_ clknet_4_14_0_clk din[5] _36_ VSS _unconnected_1076
+ _unconnected_1077 VDD mem\[9\][5] sky130_fd_sc_hd__edfxtp_1
X_401_ clknet_4_15_0_clk din[4] _36_ VSS _unconnected_1078
+ _unconnected_1079 VDD mem\[9\][4] sky130_fd_sc_hd__edfxtp_1
X_402_ clknet_4_7_0_clk din[3] _36_ VSS _unconnected_1080
+ _unconnected_1081 VDD mem\[9\][3] sky130_fd_sc_hd__edfxtp_1
X_403_ clknet_4_12_0_clk din[2] _36_ VSS _unconnected_1082
+ _unconnected_1083 VDD mem\[9\][2] sky130_fd_sc_hd__edfxtp_1
X_404_ clknet_4_8_0_clk din[7] _39_ VSS _unconnected_1084
+ _unconnected_1085 VDD mem\[6\][7] sky130_fd_sc_hd__edfxtp_1
X_405_ clknet_4_4_0_clk _16_ rst VSS _unconnected_1086 _unconnected_1087
+ VDD rd_ptr[3] sky130_fd_sc_hd__dfrtp_1
X_406_ clknet_4_1_0_clk _27_ rst VSS _unconnected_1088 _unconnected_1089
+ VDD rd_ptr[4] sky130_fd_sc_hd__dfrtp_1
X_407_ clknet_4_5_0_clk din[1] _36_ VSS _unconnected_1090
+ _unconnected_1091 VDD mem\[9\][1] sky130_fd_sc_hd__edfxtp_1
X_408_ clknet_4_14_0_clk din[0] _36_ VSS _unconnected_1092
+ _unconnected_1093 VDD mem\[9\][0] sky130_fd_sc_hd__edfxtp_1
X_409_ clknet_4_10_0_clk din[6] _39_ VSS _unconnected_1094
+ _unconnected_1095 VDD mem\[6\][6] sky130_fd_sc_hd__edfxtp_1
X_410_ clknet_4_11_0_clk din[7] _41_ VSS _unconnected_1096
+ _unconnected_1097 VDD mem\[13\][7] sky130_fd_sc_hd__edfxtp_1
X_411_ clknet_4_10_0_clk din[5] _39_ VSS _unconnected_1098
+ _unconnected_1099 VDD mem\[6\][5] sky130_fd_sc_hd__edfxtp_1
X_412_ clknet_4_1_0_clk _28_ rst VSS _unconnected_1100 _unconnected_1101
+ VDD wr_ptr[4] sky130_fd_sc_hd__dfrtp_1
X_413_ clknet_4_8_0_clk din[7] net25 VSS _unconnected_1102
+ _unconnected_1103 VDD mem\[7\][7] sky130_fd_sc_hd__edfxtp_1
X_414_ clknet_4_2_0_clk din[4] _39_ VSS _unconnected_1104
+ _unconnected_1105 VDD mem\[6\][4] sky130_fd_sc_hd__edfxtp_1
X_415_ clknet_4_3_0_clk din[3] _39_ VSS _unconnected_1106
+ _unconnected_1107 VDD mem\[6\][3] sky130_fd_sc_hd__edfxtp_1
X_416_ clknet_4_0_0_clk din[2] _39_ VSS _unconnected_1108
+ _unconnected_1109 VDD mem\[6\][2] sky130_fd_sc_hd__edfxtp_1
X_417_ clknet_4_6_0_clk _15_ rst VSS _unconnected_1110 _unconnected_1111
+ VDD dout[0] sky130_fd_sc_hd__dfrtp_1
X_418_ clknet_4_0_0_clk din[1] _39_ VSS _unconnected_1112
+ _unconnected_1113 VDD mem\[6\][1] sky130_fd_sc_hd__edfxtp_1
X_419_ clknet_4_10_0_clk din[7] net23 VSS _unconnected_1114
+ _unconnected_1115 VDD mem\[4\][7] sky130_fd_sc_hd__edfxtp_1
X_420_ clknet_4_9_0_clk din[0] _39_ VSS _unconnected_1116
+ _unconnected_1117 VDD mem\[6\][0] sky130_fd_sc_hd__edfxtp_1
X_421_ clknet_4_6_0_clk din[6] _38_ VSS _unconnected_1118
+ _unconnected_1119 VDD mem\[14\][6] sky130_fd_sc_hd__edfxtp_1
X_422_ clknet_4_9_0_clk din[5] _38_ VSS _unconnected_1120
+ _unconnected_1121 VDD mem\[14\][5] sky130_fd_sc_hd__edfxtp_1
X_423_ clknet_4_8_0_clk din[4] _38_ VSS _unconnected_1122
+ _unconnected_1123 VDD mem\[14\][4] sky130_fd_sc_hd__edfxtp_1
X_424_ clknet_4_3_0_clk din[3] _38_ VSS _unconnected_1124
+ _unconnected_1125 VDD mem\[14\][3] sky130_fd_sc_hd__edfxtp_1
X_425_ clknet_4_8_0_clk din[7] net22 VSS _unconnected_1126
+ _unconnected_1127 VDD mem\[0\][7] sky130_fd_sc_hd__edfxtp_1
X_426_ clknet_4_6_0_clk din[2] _38_ VSS _unconnected_1128
+ _unconnected_1129 VDD mem\[14\][2] sky130_fd_sc_hd__edfxtp_1
X_427_ clknet_4_10_0_clk din[7] _31_ VSS _unconnected_1130
+ _unconnected_1131 VDD mem\[1\][7] sky130_fd_sc_hd__edfxtp_1
X_428_ clknet_4_9_0_clk din[7] _25_ VSS _unconnected_1132
+ _unconnected_1133 VDD mem\[2\][7] sky130_fd_sc_hd__edfxtp_1
X_429_ clknet_4_5_0_clk _14_ rst VSS _unconnected_1134 _unconnected_1135
+ VDD dout[1] sky130_fd_sc_hd__dfrtp_1
X_430_ clknet_4_7_0_clk _13_ rst VSS _unconnected_1136 _unconnected_1137
+ VDD dout[2] sky130_fd_sc_hd__dfrtp_1
X_431_ clknet_4_15_0_clk din[7] net27 VSS _unconnected_1138
+ _unconnected_1139 VDD mem\[8\][7] sky130_fd_sc_hd__edfxtp_1
X_432_ clknet_4_13_0_clk net42 rst VSS _unconnected_1140 _unconnected_1141
+ VDD dout[3] sky130_fd_sc_hd__dfrtp_1
X_433_ clknet_4_15_0_clk din[7] net24 VSS _unconnected_1142
+ _unconnected_1143 VDD mem\[12\][7] sky130_fd_sc_hd__edfxtp_1
X_434_ clknet_4_11_0_clk din[7] _43_ VSS _unconnected_1144
+ _unconnected_1145 VDD mem\[3\][7] sky130_fd_sc_hd__edfxtp_1
X_435_ clknet_4_13_0_clk din[7] _36_ VSS _unconnected_1146
+ _unconnected_1147 VDD mem\[9\][7] sky130_fd_sc_hd__edfxtp_1
X_436_ clknet_4_13_0_clk _42_ rst VSS _unconnected_1148 _unconnected_1149
+ VDD dout[4] sky130_fd_sc_hd__dfrtp_1
X_437_ clknet_4_15_0_clk _44_ rst VSS _unconnected_1150 _unconnected_1151
+ VDD dout[5] sky130_fd_sc_hd__dfrtp_1
X_438_ clknet_4_10_0_clk din[7] _35_ VSS _unconnected_1152
+ _unconnected_1153 VDD mem\[5\][7] sky130_fd_sc_hd__edfxtp_1
X_439_ clknet_4_15_0_clk net45 rst VSS _unconnected_1154 _unconnected_1155
+ VDD dout[6] sky130_fd_sc_hd__dfrtp_1
X_440_ clknet_4_13_0_clk din[7] _30_ VSS _unconnected_1156
+ _unconnected_1157 VDD mem\[10\][7] sky130_fd_sc_hd__edfxtp_1
X_441_ clknet_4_15_0_clk din[7] _32_ VSS _unconnected_1158
+ _unconnected_1159 VDD mem\[15\][7] sky130_fd_sc_hd__edfxtp_1
X_442_ clknet_4_13_0_clk din[7] net26 VSS _unconnected_1160
+ _unconnected_1161 VDD mem\[11\][7] sky130_fd_sc_hd__edfxtp_1
X_443_ clknet_4_15_0_clk _24_ rst VSS _unconnected_1162 _unconnected_1163
+ VDD dout[7] sky130_fd_sc_hd__dfrtp_1
X_444_ clknet_4_9_0_clk din[7] _38_ VSS _unconnected_1164
+ _unconnected_1165 VDD mem\[14\][7] sky130_fd_sc_hd__edfxtp_1
X_445_ clknet_4_1_0_clk _22_ rst VSS _unconnected_1166 _unconnected_1167
+ VDD wr_ptr[1] sky130_fd_sc_hd__dfrtp_1
X_446_ clknet_4_0_0_clk din[1] _38_ VSS _unconnected_1168
+ _unconnected_1169 VDD mem\[14\][1] sky130_fd_sc_hd__edfxtp_1
X_447_ clknet_4_4_0_clk _19_ rst VSS _unconnected_1170 _unconnected_1171
+ VDD rd_ptr[0] sky130_fd_sc_hd__dfrtp_1
X_448_ clknet_4_14_0_clk din[6] _41_ VSS _unconnected_1172
+ _unconnected_1173 VDD mem\[13\][6] sky130_fd_sc_hd__edfxtp_1
X_449_ clknet_4_3_0_clk din[5] _41_ VSS _unconnected_1174
+ _unconnected_1175 VDD mem\[13\][5] sky130_fd_sc_hd__edfxtp_1
X_450_ clknet_4_13_0_clk din[4] _41_ VSS _unconnected_1176
+ _unconnected_1177 VDD mem\[13\][4] sky130_fd_sc_hd__edfxtp_1
X_451_ clknet_4_2_0_clk din[3] _41_ VSS _unconnected_1178
+ _unconnected_1179 VDD mem\[13\][3] sky130_fd_sc_hd__edfxtp_1
X_452_ clknet_4_9_0_clk din[2] _41_ VSS _unconnected_1180
+ _unconnected_1181 VDD mem\[13\][2] sky130_fd_sc_hd__edfxtp_1
X_453_ clknet_4_0_0_clk _21_ rst VSS _unconnected_1182 _unconnected_1183
+ VDD wr_ptr[2] sky130_fd_sc_hd__dfrtp_1
X_454_ clknet_4_5_0_clk din[1] _41_ VSS _unconnected_1184
+ _unconnected_1185 VDD mem\[13\][1] sky130_fd_sc_hd__edfxtp_1
X_455_ clknet_4_3_0_clk din[0] _41_ VSS _unconnected_1186
+ _unconnected_1187 VDD mem\[13\][0] sky130_fd_sc_hd__edfxtp_1
X_456_ clknet_4_12_0_clk din[6] net26 VSS _unconnected_1188
+ _unconnected_1189 VDD mem\[11\][6] sky130_fd_sc_hd__edfxtp_1
X_457_ clknet_4_12_0_clk din[5] net26 VSS _unconnected_1190
+ _unconnected_1191 VDD mem\[11\][5] sky130_fd_sc_hd__edfxtp_1
X_458_ clknet_4_13_0_clk din[4] net26 VSS _unconnected_1192
+ _unconnected_1193 VDD mem\[11\][4] sky130_fd_sc_hd__edfxtp_1
X_459_ clknet_4_7_0_clk din[3] net26 VSS _unconnected_1194
+ _unconnected_1195 VDD mem\[11\][3] sky130_fd_sc_hd__edfxtp_1
X_460_ clknet_4_12_0_clk din[2] net26 VSS _unconnected_1196
+ _unconnected_1197 VDD mem\[11\][2] sky130_fd_sc_hd__edfxtp_1
X_461_ clknet_4_0_0_clk _20_ rst VSS _unconnected_1198 _unconnected_1199
+ VDD wr_ptr[3] sky130_fd_sc_hd__dfrtp_1
X_462_ clknet_4_12_0_clk din[0] net26 VSS _unconnected_1200
+ _unconnected_1201 VDD mem\[11\][0] sky130_fd_sc_hd__edfxtp_1
X_463_ clknet_4_9_0_clk din[0] _38_ VSS _unconnected_1202
+ _unconnected_1203 VDD mem\[14\][0] sky130_fd_sc_hd__edfxtp_1
X_464_ clknet_4_14_0_clk din[6] _32_ VSS _unconnected_1204
+ _unconnected_1205 VDD mem\[15\][6] sky130_fd_sc_hd__edfxtp_1
X_465_ clknet_4_11_0_clk din[5] _32_ VSS _unconnected_1206
+ _unconnected_1207 VDD mem\[15\][5] sky130_fd_sc_hd__edfxtp_1
X_466_ clknet_4_5_0_clk din[1] net26 VSS _unconnected_1208
+ _unconnected_1209 VDD mem\[11\][1] sky130_fd_sc_hd__edfxtp_1
X_467_ clknet_4_1_0_clk _23_ rst VSS _unconnected_1210 _unconnected_1211
+ VDD wr_ptr[0] sky130_fd_sc_hd__dfrtp_1
X_468_ clknet_4_8_0_clk din[6] net25 VSS _unconnected_1212
+ _unconnected_1213 VDD mem\[7\][6] sky130_fd_sc_hd__edfxtp_1
X_469_ clknet_4_14_0_clk din[5] _33_ VSS _unconnected_1214
+ _unconnected_1215 VDD mem\[7\][5] sky130_fd_sc_hd__edfxtp_1
Xclkbuf_0_clk clk _unconnected_1216 _unconnected_1217 _unconnected_1218
+ _unconnected_1219 clknet_0_clk sky130_fd_sc_hd__clkbuf_16
Xclkbuf_4_0_0_clk clknet_0_clk _unconnected_1220 _unconnected_1221
+ _unconnected_1222 _unconnected_1223 clknet_4_0_0_clk sky130_fd_sc_hd__clkbuf_16
Xclkbuf_4_10_0_clk clknet_0_clk _unconnected_1224 _unconnected_1225
+ _unconnected_1226 _unconnected_1227 clknet_4_10_0_clk sky130_fd_sc_hd__clkbuf_16
Xclkbuf_4_11_0_clk clknet_0_clk _unconnected_1228 _unconnected_1229
+ _unconnected_1230 _unconnected_1231 clknet_4_11_0_clk sky130_fd_sc_hd__clkbuf_16
Xclkbuf_4_12_0_clk clknet_0_clk _unconnected_1232 _unconnected_1233
+ _unconnected_1234 _unconnected_1235 clknet_4_12_0_clk sky130_fd_sc_hd__clkbuf_16
Xclkbuf_4_13_0_clk clknet_0_clk _unconnected_1236 _unconnected_1237
+ _unconnected_1238 _unconnected_1239 clknet_4_13_0_clk sky130_fd_sc_hd__clkbuf_16
Xclkbuf_4_14_0_clk clknet_0_clk _unconnected_1240 _unconnected_1241
+ _unconnected_1242 _unconnected_1243 clknet_4_14_0_clk sky130_fd_sc_hd__clkbuf_16
Xclkbuf_4_15_0_clk clknet_0_clk _unconnected_1244 _unconnected_1245
+ _unconnected_1246 _unconnected_1247 clknet_4_15_0_clk sky130_fd_sc_hd__clkbuf_16
Xclkbuf_4_1_0_clk clknet_0_clk _unconnected_1248 _unconnected_1249
+ _unconnected_1250 _unconnected_1251 clknet_4_1_0_clk sky130_fd_sc_hd__clkbuf_16
Xclkbuf_4_2_0_clk clknet_0_clk _unconnected_1252 _unconnected_1253
+ _unconnected_1254 _unconnected_1255 clknet_4_2_0_clk sky130_fd_sc_hd__clkbuf_16
Xclkbuf_4_3_0_clk clknet_0_clk _unconnected_1256 _unconnected_1257
+ _unconnected_1258 _unconnected_1259 clknet_4_3_0_clk sky130_fd_sc_hd__clkbuf_16
Xclkbuf_4_4_0_clk clknet_0_clk _unconnected_1260 _unconnected_1261
+ _unconnected_1262 _unconnected_1263 clknet_4_4_0_clk sky130_fd_sc_hd__clkbuf_16
Xclkbuf_4_5_0_clk clknet_0_clk _unconnected_1264 _unconnected_1265
+ _unconnected_1266 _unconnected_1267 clknet_4_5_0_clk sky130_fd_sc_hd__clkbuf_16
Xclkbuf_4_6_0_clk clknet_0_clk _unconnected_1268 _unconnected_1269
+ _unconnected_1270 _unconnected_1271 clknet_4_6_0_clk sky130_fd_sc_hd__clkbuf_16
Xclkbuf_4_7_0_clk clknet_0_clk _unconnected_1272 _unconnected_1273
+ _unconnected_1274 _unconnected_1275 clknet_4_7_0_clk sky130_fd_sc_hd__clkbuf_16
Xclkbuf_4_8_0_clk clknet_0_clk _unconnected_1276 _unconnected_1277
+ _unconnected_1278 _unconnected_1279 clknet_4_8_0_clk sky130_fd_sc_hd__clkbuf_16
Xclkbuf_4_9_0_clk clknet_0_clk _unconnected_1280 _unconnected_1281
+ _unconnected_1282 _unconnected_1283 clknet_4_9_0_clk sky130_fd_sc_hd__clkbuf_16
Xclkload0 clknet_4_0_0_clk _unconnected_1284 _unconnected_1285
+ _unconnected_1286 _unconnected_1287 _unconnected_1288 sky130_fd_sc_hd__clkinv_2
Xclkload1 clknet_4_1_0_clk _unconnected_1289 _unconnected_1290
+ _unconnected_1291 _unconnected_1292 _unconnected_1293 sky130_fd_sc_hd__inv_4
Xclkload10 clknet_4_10_0_clk _unconnected_1294 _unconnected_1295
+ _unconnected_1296 _unconnected_1297 _unconnected_1298 sky130_fd_sc_hd__inv_1
Xclkload11 clknet_4_11_0_clk _unconnected_1299 _unconnected_1300
+ _unconnected_1301 _unconnected_1302 _unconnected_1303 sky130_fd_sc_hd__clkinvlp_2
Xclkload12 clknet_4_13_0_clk _unconnected_1304 _unconnected_1305
+ _unconnected_1306 _unconnected_1307 _unconnected_1308 sky130_fd_sc_hd__clkinvlp_2
Xclkload13 clknet_4_14_0_clk _unconnected_1309 _unconnected_1310
+ _unconnected_1311 _unconnected_1312 _unconnected_1313 sky130_fd_sc_hd__clkinvlp_2
Xclkload14 clknet_4_15_0_clk _unconnected_1314 _unconnected_1315
+ _unconnected_1316 _unconnected_1317 _unconnected_1318 sky130_fd_sc_hd__inv_1
Xclkload2 clknet_4_2_0_clk _unconnected_1319 _unconnected_1320
+ _unconnected_1321 _unconnected_1322 _unconnected_1323 sky130_fd_sc_hd__clkinvlp_4
Xclkload3 clknet_4_3_0_clk _unconnected_1324 _unconnected_1325
+ _unconnected_1326 _unconnected_1327 _unconnected_1328 sky130_fd_sc_hd__clkinvlp_4
Xclkload4 clknet_4_4_0_clk _unconnected_1329 _unconnected_1330
+ _unconnected_1331 _unconnected_1332 _unconnected_1333 sky130_fd_sc_hd__clkinv_4
Xclkload5 clknet_4_5_0_clk _unconnected_1334 _unconnected_1335
+ _unconnected_1336 _unconnected_1337 _unconnected_1338 sky130_fd_sc_hd__inv_4
Xclkload6 clknet_4_6_0_clk _unconnected_1339 _unconnected_1340
+ _unconnected_1341 _unconnected_1342 _unconnected_1343 sky130_fd_sc_hd__inv_4
Xclkload7 clknet_4_7_0_clk _unconnected_1344 _unconnected_1345
+ _unconnected_1346 _unconnected_1347 _unconnected_1348 sky130_fd_sc_hd__clkinvlp_2
Xclkload8 clknet_4_8_0_clk _unconnected_1349 _unconnected_1350
+ _unconnected_1351 _unconnected_1352 _unconnected_1353 sky130_fd_sc_hd__clkinv_2
Xclkload9 clknet_4_9_0_clk _unconnected_1354 _unconnected_1355
+ _unconnected_1356 _unconnected_1357 _unconnected_1358 sky130_fd_sc_hd__inv_1
Xhold40 mem\[8\][3] _unconnected_1359 _unconnected_1360 _unconnected_1361
+ _unconnected_1362 net40 sky130_fd_sc_hd__dlygate4sd3_1
Xhold41 _105_ _unconnected_1363 _unconnected_1364 _unconnected_1365
+ _unconnected_1366 net41 sky130_fd_sc_hd__dlygate4sd3_1
Xhold42 _12_ _unconnected_1367 _unconnected_1368 _unconnected_1369
+ _unconnected_1370 net42 sky130_fd_sc_hd__dlygate4sd3_1
Xhold43 mem\[0\][6] _unconnected_1371 _unconnected_1372 _unconnected_1373
+ _unconnected_1374 net43 sky130_fd_sc_hd__dlygate4sd3_1
Xhold44 _71_ _unconnected_1375 _unconnected_1376 _unconnected_1377
+ _unconnected_1378 net44 sky130_fd_sc_hd__dlygate4sd3_1
Xhold45 _11_ _unconnected_1379 _unconnected_1380 _unconnected_1381
+ _unconnected_1382 net45 sky130_fd_sc_hd__dlygate4sd3_1
Xhold46 mem\[8\][5] _unconnected_1383 _unconnected_1384 _unconnected_1385
+ _unconnected_1386 net46 sky130_fd_sc_hd__dlygate4sd3_1
Xhold47 _81_ _unconnected_1387 _unconnected_1388 _unconnected_1389
+ _unconnected_1390 net47 sky130_fd_sc_hd__dlygate4sd3_1
Xhold48 _87_ _unconnected_1391 _unconnected_1392 _unconnected_1393
+ _unconnected_1394 net48 sky130_fd_sc_hd__dlygate4sd3_1
Xhold49 mem\[4\][2] _unconnected_1395 _unconnected_1396 _unconnected_1397
+ _unconnected_1398 net49 sky130_fd_sc_hd__dlygate4sd3_1
Xhold50 _118_ _unconnected_1399 _unconnected_1400 _unconnected_1401
+ _unconnected_1402 net50 sky130_fd_sc_hd__dlygate4sd3_1
Xhold51 _119_ _unconnected_1403 _unconnected_1404 _unconnected_1405
+ _unconnected_1406 net51 sky130_fd_sc_hd__dlygate4sd3_1
Xhold52 mem\[3\][7] _unconnected_1407 _unconnected_1408 _unconnected_1409
+ _unconnected_1410 net52 sky130_fd_sc_hd__dlygate4sd3_1
Xhold53 _160_ _unconnected_1411 _unconnected_1412 _unconnected_1413
+ _unconnected_1414 net53 sky130_fd_sc_hd__dlygate4sd3_1
Xhold54 _4_ _unconnected_1415 _unconnected_1416 _unconnected_1417
+ _unconnected_1418 net54 sky130_fd_sc_hd__dlygate4sd3_1
Xhold55 mem\[6\][0] _unconnected_1419 _unconnected_1420 _unconnected_1421
+ _unconnected_1422 net55 sky130_fd_sc_hd__dlygate4sd3_1
Xhold56 _137_ _unconnected_1423 _unconnected_1424 _unconnected_1425
+ _unconnected_1426 net56 sky130_fd_sc_hd__dlygate4sd3_1
Xhold57 _142_ _unconnected_1427 _unconnected_1428 _unconnected_1429
+ _unconnected_1430 net57 sky130_fd_sc_hd__dlygate4sd3_1
Xhold58 mem\[8\][4] _unconnected_1431 _unconnected_1432 _unconnected_1433
+ _unconnected_1434 net58 sky130_fd_sc_hd__dlygate4sd3_1
Xhold59 _97_ _unconnected_1435 _unconnected_1436 _unconnected_1437
+ _unconnected_1438 net59 sky130_fd_sc_hd__dlygate4sd3_1
Xhold60 _98_ _unconnected_1439 _unconnected_1440 _unconnected_1441
+ _unconnected_1442 net60 sky130_fd_sc_hd__dlygate4sd3_1
Xhold61 mem\[8\][1] _unconnected_1443 _unconnected_1444 _unconnected_1445
+ _unconnected_1446 net61 sky130_fd_sc_hd__dlygate4sd3_1
Xhold62 _129_ _unconnected_1447 _unconnected_1448 _unconnected_1449
+ _unconnected_1450 net62 sky130_fd_sc_hd__dlygate4sd3_1
Xhold63 _130_ _unconnected_1451 _unconnected_1452 _unconnected_1453
+ _unconnected_1454 net63 sky130_fd_sc_hd__dlygate4sd3_1
Xhold64 wr_ptr[1] _unconnected_1455 _unconnected_1456 _unconnected_1457
+ _unconnected_1458 net64 sky130_fd_sc_hd__dlygate4sd3_1
Xhold65 _154_ _unconnected_1459 _unconnected_1460 _unconnected_1461
+ _unconnected_1462 net65 sky130_fd_sc_hd__dlygate4sd3_1
Xhold66 wr_ptr[0] _unconnected_1463 _unconnected_1464 _unconnected_1465
+ _unconnected_1466 net66 sky130_fd_sc_hd__dlygate4sd3_1
Xplace21 _40_ _unconnected_1467 _unconnected_1468 _unconnected_1469
+ _unconnected_1470 net21 sky130_fd_sc_hd__buf_4
Xplace22 _40_ _unconnected_1471 _unconnected_1472 _unconnected_1473
+ _unconnected_1474 net22 sky130_fd_sc_hd__buf_4
Xplace23 _37_ _unconnected_1475 _unconnected_1476 _unconnected_1477
+ _unconnected_1478 net23 sky130_fd_sc_hd__buf_4
Xplace24 _34_ _unconnected_1479 _unconnected_1480 _unconnected_1481
+ _unconnected_1482 net24 sky130_fd_sc_hd__buf_4
Xplace25 _33_ _unconnected_1483 _unconnected_1484 _unconnected_1485
+ _unconnected_1486 net25 sky130_fd_sc_hd__buf_4
Xplace26 _29_ _unconnected_1487 _unconnected_1488 _unconnected_1489
+ _unconnected_1490 net26 sky130_fd_sc_hd__buf_4
Xplace27 _26_ _unconnected_1491 _unconnected_1492 _unconnected_1493
+ _unconnected_1494 net27 sky130_fd_sc_hd__buf_4
Xplace28 _147_ _unconnected_1495 _unconnected_1496 _unconnected_1497
+ _unconnected_1498 net28 sky130_fd_sc_hd__buf_4
Xplace29 _52_ _unconnected_1499 _unconnected_1500 _unconnected_1501
+ _unconnected_1502 net29 sky130_fd_sc_hd__buf_4
Xplace30 _70_ _unconnected_1503 _unconnected_1504 _unconnected_1505
+ _unconnected_1506 net30 sky130_fd_sc_hd__buf_4
Xplace31 _66_ _unconnected_1507 _unconnected_1508 _unconnected_1509
+ _unconnected_1510 net31 sky130_fd_sc_hd__buf_4
Xplace32 _64_ _unconnected_1511 _unconnected_1512 _unconnected_1513
+ _unconnected_1514 net32 sky130_fd_sc_hd__buf_4
Xplace33 _63_ _unconnected_1515 _unconnected_1516 _unconnected_1517
+ _unconnected_1518 net33 sky130_fd_sc_hd__buf_4
Xplace34 _62_ _unconnected_1519 _unconnected_1520 _unconnected_1521
+ _unconnected_1522 net34 sky130_fd_sc_hd__buf_4
Xplace35 _61_ _unconnected_1523 _unconnected_1524 _unconnected_1525
+ _unconnected_1526 net35 sky130_fd_sc_hd__buf_4
Xplace36 _58_ _unconnected_1527 _unconnected_1528 _unconnected_1529
+ _unconnected_1530 net36 sky130_fd_sc_hd__buf_4
Xplace37 _56_ _unconnected_1531 _unconnected_1532 _unconnected_1533
+ _unconnected_1534 net37 sky130_fd_sc_hd__buf_4
Xplace38 _55_ _unconnected_1535 _unconnected_1536 _unconnected_1537
+ _unconnected_1538 net38 sky130_fd_sc_hd__buf_4
Xplace39 _54_ _unconnected_1539 _unconnected_1540 _unconnected_1541
+ _unconnected_1542 net39 sky130_fd_sc_hd__buf_4
.ENDS Sync_FIFO_async_rst
